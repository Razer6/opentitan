// Copyright lowRISC contributors (OpenTitan project).
// Licensed under the Apache License, Version 2.0, see LICENSE for details.
// SPDX-License-Identifier: Apache-2.0

# RACL Control register template
#
{
  name:               "racl_ctrl_lioGrpD",
  human_name:         "RACL Control",
  one_line_desc:      "Implements the RACL policy registers to distribute to subscribing IPs.",
  one_paragraph_desc: '''
  Implements the RACL policy registers to distribute to subscribing IPs.
  '''
  // Unique comportable IP identifier defined under KNOWN_CIP_IDS in the regtool.
  cip_id:             "43",
  design_spec:        "../doc",
  dv_doc:             "../doc/dv",
  hw_checklist:       "../doc/checklist",
  sw_checklist:       "/sw/device/lib/dif/dif_racl_ctrl",
  revisions: [
    {
      version:            "1.0.0",
      life_stage:         "L1",
      design_stage:       "D0",
      verification_stage: "V0",
      dif_stage:          "S0",
    }
  ]
  clocking: [
    {clock: "clk_i", reset: "rst_ni"},
  ]
  bus_interfaces: [
    { protocol: "tlul", direction: "device", static_racl_support: true }
  ],
  // In order to not disturb the racl_ctrl address map, we place the alert test and interrupt
  // registers manually at a safe offset after the main CSRs.
  // TODO(#26748) Add tooling support to avoid manual placement of alert/interrupt registers
  no_auto_intr_regs: "True",
  no_auto_alert_regs: "True",
  interrupt_list: [
    { name: "racl_error",
      desc: "RACL error has occurred.",
      type: "status"
    }
  ]
  alert_list: [
    { name: "fatal_fault"
      desc: "This fatal alert is triggered when a fatal TL-UL bus integrity fault is detected."
    }
    { name: "recov_ctrl_update_err",
      desc: "This recoverable alert is triggered upon detecting an update error in the shadowed Control Register."
    }
  ],
  countermeasures: [
    { name: "BUS.INTEGRITY",
      desc: "End-to-end bus integrity scheme."
    }
    { name: "RACL_POLICY.CONFIG.SHADOW",
      desc: "RACL policy registers are shadowed."
    }
  ]
  regwidth: "32",
  param_list: [
    { name: "NumSubscribingIps",
      desc: "Number of subscribing RACL IPs",
      type: "int",
      default: "1",
      expose: "true"
      local: "true"
    },
    { name: "NumExternalSubscribingIps",
      desc: "Number of external subscribing RACL IPs",
      type: "int",
      default: "1",
      expose: "true"
      local: "false"
    },
  ],
  inter_signal_list: [
    { struct:  "racl_policy_vec",
      type:    "uni",
      name:    "racl_policies",
      act:     "req",
      package: "top_racl_pkg",
      desc:    '''
        Policy vector distributed to the subscribing RACL IPs.
      '''
    }
    { struct:  "racl_error_log",
      type:    "uni",
      name:    "racl_error",
      act:     "rcv",
      width:   "NumSubscribingIps"
      package: "top_racl_pkg",
      desc:    '''
        Error log information from all IPs.
        Only one IP can raise an error at a time.
      '''
    }
    { struct:  "racl_error_log",
      type:    "uni",
      name:    "racl_error_external",
      act:     "rcv",
      width:   "NumExternalSubscribingIps"
      package: "top_racl_pkg",
      desc:    '''
        Error log information from all external IPs.
        Only one IP can raise an error at a time.
      '''
    }
  ],

  registers: [
    { name: "POLICY_ALL_RD_WR_POLICY_SHADOWED"
      desc: '''
            Read and write policy for all_rd_wr_policy
            '''
      swaccess: "rw"
      hwaccess: "hro"
      shadowed: "true"
      update_err_alert: "recov_ctrl_update_err"
      storage_err_alert: "fatal_fault"
      fields: [
        { bits: "31:16"
          name: "write_perm"
          resval: 16383
          desc: '''
                Write permission for policy all_rd_wr_policy
                '''
        }
        { bits: "15:0"
          name: "read_perm"
          resval: 16383
          desc: '''
                Read permission for policy all_rd_wr_policy
                '''
        }
      ]
      tags: [
        "racl_ctrl_policy_name:lioGrpD:all_rd_wr_policy"
      ],
    }
    { reserved: "1" }
    { name: "POLICY_ROT_PRIVATE_POLICY_SHADOWED"
      desc: '''
            Read and write policy for rot_private_policy
            '''
      swaccess: "rw"
      hwaccess: "hro"
      shadowed: "true"
      update_err_alert: "recov_ctrl_update_err"
      storage_err_alert: "fatal_fault"
      fields: [
        { bits: "31:16"
          name: "write_perm"
          resval: 96
          desc: '''
                Write permission for policy rot_private_policy
                '''
        }
        { bits: "15:0"
          name: "read_perm"
          resval: 96
          desc: '''
                Read permission for policy rot_private_policy
                '''
        }
      ]
      tags: [
        "racl_ctrl_policy_name:lioGrpD:rot_private_policy"
      ],
    }
    { reserved: "1" }
    { name: "POLICY_HW_ROT_PWC_WR_ALL_RD_POLICY_SHADOWED"
      desc: '''
            Read and write policy for hw_rot_pwc_wr_all_rd_policy
            '''
      swaccess: "rw"
      hwaccess: "hro"
      shadowed: "true"
      update_err_alert: "recov_ctrl_update_err"
      storage_err_alert: "fatal_fault"
      fields: [
        { bits: "31:16"
          name: "write_perm"
          resval: 864
          desc: '''
                Write permission for policy hw_rot_pwc_wr_all_rd_policy
                '''
        }
        { bits: "15:0"
          name: "read_perm"
          resval: 16383
          desc: '''
                Read permission for policy hw_rot_pwc_wr_all_rd_policy
                '''
        }
      ]
      tags: [
        "racl_ctrl_policy_name:lioGrpD:hw_rot_pwc_wr_all_rd_policy"
      ],
    }
    { reserved: "1" }
    { name: "POLICY_PWC_PRIVATE_POLICY_SHADOWED"
      desc: '''
            Read and write policy for pwc_private_policy
            '''
      swaccess: "rw"
      hwaccess: "hro"
      shadowed: "true"
      update_err_alert: "recov_ctrl_update_err"
      storage_err_alert: "fatal_fault"
      fields: [
        { bits: "31:16"
          name: "write_perm"
          resval: 864
          desc: '''
                Write permission for policy pwc_private_policy
                '''
        }
        { bits: "15:0"
          name: "read_perm"
          resval: 864
          desc: '''
                Read permission for policy pwc_private_policy
                '''
        }
      ]
      tags: [
        "racl_ctrl_policy_name:lioGrpD:pwc_private_policy"
      ],
    }
    { reserved: "1" }
    { name: "POLICY_MIO_PRIVATE_POLICY_SHADOWED"
      desc: '''
            Read and write policy for mio_private_policy
            '''
      swaccess: "rw"
      hwaccess: "hro"
      shadowed: "true"
      update_err_alert: "recov_ctrl_update_err"
      storage_err_alert: "fatal_fault"
      fields: [
        { bits: "31:16"
          name: "write_perm"
          resval: 992
          desc: '''
                Write permission for policy mio_private_policy
                '''
        }
        { bits: "15:0"
          name: "read_perm"
          resval: 992
          desc: '''
                Read permission for policy mio_private_policy
                '''
        }
      ]
      tags: [
        "racl_ctrl_policy_name:lioGrpD:mio_private_policy"
      ],
    }
    { reserved: "1" }
    { name: "POLICY_PWMPOLICY_SHADOWED"
      desc: '''
            Read and write policy for pwmPolicy
            '''
      swaccess: "rw"
      hwaccess: "hro"
      shadowed: "true"
      update_err_alert: "recov_ctrl_update_err"
      storage_err_alert: "fatal_fault"
      fields: [
        { bits: "31:16"
          name: "write_perm"
          resval: 16383
          desc: '''
                Write permission for policy pwmPolicy
                '''
        }
        { bits: "15:0"
          name: "read_perm"
          resval: 16383
          desc: '''
                Read permission for policy pwmPolicy
                '''
        }
      ]
      tags: [
        "racl_ctrl_policy_name:lioGrpD:pwmPolicy"
      ],
    }
    { reserved: "1" }
    { name: "POLICY_GPIOPOLICY_SHADOWED"
      desc: '''
            Read and write policy for gpioPolicy
            '''
      swaccess: "rw"
      hwaccess: "hro"
      shadowed: "true"
      update_err_alert: "recov_ctrl_update_err"
      storage_err_alert: "fatal_fault"
      fields: [
        { bits: "31:16"
          name: "write_perm"
          resval: 16383
          desc: '''
                Write permission for policy gpioPolicy
                '''
        }
        { bits: "15:0"
          name: "read_perm"
          resval: 16383
          desc: '''
                Read permission for policy gpioPolicy
                '''
        }
      ]
      tags: [
        "racl_ctrl_policy_name:lioGrpD:gpioPolicy"
      ],
    }
    { reserved: "1" }
    { name: "POLICY_UARTPOLICY_SHADOWED"
      desc: '''
            Read and write policy for uartPolicy
            '''
      swaccess: "rw"
      hwaccess: "hro"
      shadowed: "true"
      update_err_alert: "recov_ctrl_update_err"
      storage_err_alert: "fatal_fault"
      fields: [
        { bits: "31:16"
          name: "write_perm"
          resval: 16383
          desc: '''
                Write permission for policy uartPolicy
                '''
        }
        { bits: "15:0"
          name: "read_perm"
          resval: 16383
          desc: '''
                Read permission for policy uartPolicy
                '''
        }
      ]
      tags: [
        "racl_ctrl_policy_name:lioGrpD:uartPolicy"
      ],
    }
    { reserved: "1" }
    { name: "POLICY_I2C0POLICY_SHADOWED"
      desc: '''
            Read and write policy for i2c0Policy
            '''
      swaccess: "rw"
      hwaccess: "hro"
      shadowed: "true"
      update_err_alert: "recov_ctrl_update_err"
      storage_err_alert: "fatal_fault"
      fields: [
        { bits: "31:16"
          name: "write_perm"
          resval: 16383
          desc: '''
                Write permission for policy i2c0Policy
                '''
        }
        { bits: "15:0"
          name: "read_perm"
          resval: 16383
          desc: '''
                Read permission for policy i2c0Policy
                '''
        }
      ]
      tags: [
        "racl_ctrl_policy_name:lioGrpD:i2c0Policy"
      ],
    }
    { reserved: "1" }
    { name: "POLICY_I2C1POLICY_SHADOWED"
      desc: '''
            Read and write policy for i2c1Policy
            '''
      swaccess: "rw"
      hwaccess: "hro"
      shadowed: "true"
      update_err_alert: "recov_ctrl_update_err"
      storage_err_alert: "fatal_fault"
      fields: [
        { bits: "31:16"
          name: "write_perm"
          resval: 16383
          desc: '''
                Write permission for policy i2c1Policy
                '''
        }
        { bits: "15:0"
          name: "read_perm"
          resval: 16383
          desc: '''
                Read permission for policy i2c1Policy
                '''
        }
      ]
      tags: [
        "racl_ctrl_policy_name:lioGrpD:i2c1Policy"
      ],
    }
    { reserved: "1" }
    { name: "POLICY_I2C2POLICY_SHADOWED"
      desc: '''
            Read and write policy for i2c2Policy
            '''
      swaccess: "rw"
      hwaccess: "hro"
      shadowed: "true"
      update_err_alert: "recov_ctrl_update_err"
      storage_err_alert: "fatal_fault"
      fields: [
        { bits: "31:16"
          name: "write_perm"
          resval: 16383
          desc: '''
                Write permission for policy i2c2Policy
                '''
        }
        { bits: "15:0"
          name: "read_perm"
          resval: 16383
          desc: '''
                Read permission for policy i2c2Policy
                '''
        }
      ]
      tags: [
        "racl_ctrl_policy_name:lioGrpD:i2c2Policy"
      ],
    }
    { reserved: "1" }
    { name: "POLICY_I3C0POLICY_SHADOWED"
      desc: '''
            Read and write policy for i3c0Policy
            '''
      swaccess: "rw"
      hwaccess: "hro"
      shadowed: "true"
      update_err_alert: "recov_ctrl_update_err"
      storage_err_alert: "fatal_fault"
      fields: [
        { bits: "31:16"
          name: "write_perm"
          resval: 16383
          desc: '''
                Write permission for policy i3c0Policy
                '''
        }
        { bits: "15:0"
          name: "read_perm"
          resval: 16383
          desc: '''
                Read permission for policy i3c0Policy
                '''
        }
      ]
      tags: [
        "racl_ctrl_policy_name:lioGrpD:i3c0Policy"
      ],
    }
    { reserved: "1" }
    { name: "POLICY_I3C1POLICY_SHADOWED"
      desc: '''
            Read and write policy for i3c1Policy
            '''
      swaccess: "rw"
      hwaccess: "hro"
      shadowed: "true"
      update_err_alert: "recov_ctrl_update_err"
      storage_err_alert: "fatal_fault"
      fields: [
        { bits: "31:16"
          name: "write_perm"
          resval: 16383
          desc: '''
                Write permission for policy i3c1Policy
                '''
        }
        { bits: "15:0"
          name: "read_perm"
          resval: 16383
          desc: '''
                Read permission for policy i3c1Policy
                '''
        }
      ]
      tags: [
        "racl_ctrl_policy_name:lioGrpD:i3c1Policy"
      ],
    }
    { reserved: "1" }
    { name: "POLICY_I3C2POLICY_SHADOWED"
      desc: '''
            Read and write policy for i3c2Policy
            '''
      swaccess: "rw"
      hwaccess: "hro"
      shadowed: "true"
      update_err_alert: "recov_ctrl_update_err"
      storage_err_alert: "fatal_fault"
      fields: [
        { bits: "31:16"
          name: "write_perm"
          resval: 16383
          desc: '''
                Write permission for policy i3c2Policy
                '''
        }
        { bits: "15:0"
          name: "read_perm"
          resval: 16383
          desc: '''
                Read permission for policy i3c2Policy
                '''
        }
      ]
      tags: [
        "racl_ctrl_policy_name:lioGrpD:i3c2Policy"
      ],
    }
    { reserved: "1" }
    { name: "POLICY_SPIHSTPOLICY_SHADOWED"
      desc: '''
            Read and write policy for spihstPolicy
            '''
      swaccess: "rw"
      hwaccess: "hro"
      shadowed: "true"
      update_err_alert: "recov_ctrl_update_err"
      storage_err_alert: "fatal_fault"
      fields: [
        { bits: "31:16"
          name: "write_perm"
          resval: 16383
          desc: '''
                Write permission for policy spihstPolicy
                '''
        }
        { bits: "15:0"
          name: "read_perm"
          resval: 16383
          desc: '''
                Read permission for policy spihstPolicy
                '''
        }
      ]
      tags: [
        "racl_ctrl_policy_name:lioGrpD:spihstPolicy"
      ],
    }
    { reserved: "1" }
    { name: "POLICY_SPIDEVPOLICY_SHADOWED"
      desc: '''
            Read and write policy for spidevPolicy
            '''
      swaccess: "rw"
      hwaccess: "hro"
      shadowed: "true"
      update_err_alert: "recov_ctrl_update_err"
      storage_err_alert: "fatal_fault"
      fields: [
        { bits: "31:16"
          name: "write_perm"
          resval: 16383
          desc: '''
                Write permission for policy spidevPolicy
                '''
        }
        { bits: "15:0"
          name: "read_perm"
          resval: 16383
          desc: '''
                Read permission for policy spidevPolicy
                '''
        }
      ]
      tags: [
        "racl_ctrl_policy_name:lioGrpD:spidevPolicy"
      ],
    }
    { reserved: "1" }
    { name: "POLICY_PLICPOLICY_SHADOWED"
      desc: '''
            Read and write policy for plicPolicy
            '''
      swaccess: "rw"
      hwaccess: "hro"
      shadowed: "true"
      update_err_alert: "recov_ctrl_update_err"
      storage_err_alert: "fatal_fault"
      fields: [
        { bits: "31:16"
          name: "write_perm"
          resval: 16383
          desc: '''
                Write permission for policy plicPolicy
                '''
        }
        { bits: "15:0"
          name: "read_perm"
          resval: 16383
          desc: '''
                Read permission for policy plicPolicy
                '''
        }
      ]
      tags: [
        "racl_ctrl_policy_name:lioGrpD:plicPolicy"
      ],
    }
    { reserved: "1" }
    { name: "POLICY_TIMERPOLICY_SHADOWED"
      desc: '''
            Read and write policy for timerPolicy
            '''
      swaccess: "rw"
      hwaccess: "hro"
      shadowed: "true"
      update_err_alert: "recov_ctrl_update_err"
      storage_err_alert: "fatal_fault"
      fields: [
        { bits: "31:16"
          name: "write_perm"
          resval: 16383
          desc: '''
                Write permission for policy timerPolicy
                '''
        }
        { bits: "15:0"
          name: "read_perm"
          resval: 16383
          desc: '''
                Read permission for policy timerPolicy
                '''
        }
      ]
      tags: [
        "racl_ctrl_policy_name:lioGrpD:timerPolicy"
      ],
    }
    { reserved: "1" }
    { skipto: "0xE8" }
    { name: "INTR_STATE",
      desc: "Interrupt State Register",
      swaccess: "ro",
      hwaccess: "hrw",
      fields: [
        { bits: "0",
          name: "racl_error",
          desc: '''
                Interrupt status. The interrupt is raised when a RACL error occurs and cleared
                when error_log is cleared by writing 1 to error_log.valid."
                '''
        }
      ]
      tags: [// interrupt could be updated by HW
        "excl:CsrNonInitTests:CsrExclWriteCheck"],
    },
    { name: "INTR_ENABLE",
        desc: "Interrupt Enable Register",
        swaccess: "rw",
        hwaccess: "hro",
        fields: [
          { bits: "0",
            name: "IE",
            desc: "Interrupt Enable"
          }
        ]
    },
    { name: "INTR_TEST",
      desc: "Interrupt Test Register",
      swaccess: "wo",
      hwaccess: "hro",
      hwext: "true",
      hwqe: "true",
      fields: [
        { bits: "0",
          name: "racl_error",
          desc: "Write 1 to force racl_error interrupt",
        }
      ]
    },
    { name: "ALERT_TEST",
      desc: '''Alert Test Register.''',
      swaccess: "wo",
      hwaccess: "hro",
      hwqe:     "True",
      hwext:    "True",
      fields: [
        { bits: "0",
          name: "fatal_fault",
          desc: "'Write 1 to trigger one alert event of this kind.'",
        }
        { bits: "1",
          name: "recov_ctrl_update_err",
          desc: "'Write 1 to trigger one alert event of this kind.'",
        }
      ],
    }
    { name: "ERROR_LOG"
      desc: "Error logging registers"
      swaccess: "ro"
      hwaccess: "hwo"
      hwqe: "true"
      fields: [

        { bits: "4:0"
          name: "ctn_uid"
          resval: 0x0
          desc: '''
                CTN UID causing the error.
                '''
        }
        { bits: "18:15"
          name: "role"
          resval: 0x0
          desc: '''
                RACL role causing the error.
                '''
        }
        { bits: "19"
          name: "valid"
          resval: 0x0
          swaccess: "rw1c"
          hwaccess: "hrw"
          desc: '''
                Indicates a RACL error and the log register contains valid data.
                Writing a one clears this register and the !!ERROR_LOG_ADDRESS register.
                '''
        }
        { bits: "20"
          name: "overflow"
          resval: 0x0
          desc: '''
                Indicates a RACL error overflow when a RACL error occurred while the log register was set.
                '''
        }
        { bits: "21"
          name: "read_access"
          resval: 0x0
          desc: '''
                0: Write transfer was denied.
                1: Read transfer was denied.
                '''
        }
      ]
      tags: [
        // Don't check this register in the CSR tests. It gets written by hardware in response to
        // error reports (which are sent by the base sequence) and the CSR tests can't model its
        // value.
        "excl:CsrAllTests:CsrExclAll"
      ]
    }
    { name: "ERROR_LOG_ADDRESS"
      desc: '''Contains the bits [top_pkg::TL_AW-1:2] of the address on which a RACL violation occurred.
               The address is shifted by 2 bits since TLUL access are always 4 byte aligned.
               This register is valid if and only if the `valid` field of !!ERROR_LOG is true.
               Once valid, the address doesn't change (even if there are subsequent RACL violations) until the register gets cleared.
               This register gets cleared when SW writes `1` to the `valid` field of the !!ERROR_LOG register.
            '''
      swaccess: "ro"
      hwaccess: "hwo"
      fields: [
        { bits: "29:0"
          name: "address"
          resval: 0x0
          desc: '''
                Address on which a RACL violation occurred, shifted by 2 bits to the right.
                '''
        }
      ]
      tags: [
        // Don't check this register in the CSR tests. It gets written by hardware in response to
        // error reports (which are sent by the base sequence) and the CSR tests can't model its
        // value.
        "excl:CsrAllTests:CsrExclAll"
      ]
    }
  ]
}
