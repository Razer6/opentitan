// Copyright lowRISC contributors (OpenTitan project).
// Licensed under the Apache License, Version 2.0, see LICENSE for details.
// SPDX-License-Identifier: Apache-2.0
//
// ------------------- W A R N I N G: A U T O - G E N E R A T E D   C O D E !! -------------------//
// PLEASE DO NOT HAND-EDIT THIS FILE. IT HAS BEEN AUTO-GENERATED WITH THE FOLLOWING COMMAND:
// util/topgen.py -t hw/top_mio/data/top_mio.hjson \
//                -o hw/top_mio/
{
  name: mio
  type: top
  datawidth: "32"
  racl_config: ../../top_darjeeling/data/rivos-racl/racl.hjson
  power:
  {
    domains:
    [
      "0"
    ]
    default: "0"
    wait_for_external_reset: true
  }
  unmanaged_clocks:
  {
    ext_io_div4:
    {
      name: ext_io_div4
      signal_name: clk_ext_io_div4_i
      cg_en_signal: cg_en_ext_io_div4_i
    }
    ext_main:
    {
      name: ext_main
      signal_name: clk_ext_main_i
      cg_en_signal: cg_en_ext_main_i
    }
    ext_aon:
    {
      name: ext_aon
      signal_name: clk_ext_aon_i
      cg_en_signal: cg_en_ext_aon_i
    }
  }
  unmanaged_resets:
  {
    ext_rst_io_div4:
    {
      name: ext_rst_io_div4
      signal_name: rst_ext_rst_io_div4_i
      rst_en_signal_name: rst_en_ext_rst_io_div4_i
    }
    ext_rst_main:
    {
      name: ext_rst_main
      signal_name: rst_ext_rst_main_i
      rst_en_signal_name: rst_en_ext_rst_main_i
    }
    ext_rst_aon:
    {
      name: ext_rst_aon
      signal_name: rst_ext_rst_aon_i
      rst_en_signal_name: rst_en_ext_rst_aon_i
    }
  }
  clocks:
  {
    hier_paths:
    {
      top: clkmgr_aon_clocks.
      ext: ""
      lpg: clkmgr_aon_cg_en.
    }
    srcs:
    [
      {
        name: main
        aon: no
        freq: "100000000"
        ref: false
      }
      {
        name: io
        aon: no
        freq: "96000000"
        ref: false
      }
      {
        name: usb
        aon: no
        freq: "48000000"
        ref: false
      }
      {
        name: aon
        aon: yes
        freq: "200000"
        ref: true
      }
    ]
    derived_srcs:
    [
      {
        name: io_div2
        aon: no
        freq: "48000000"
        ref: false
        div: "2"
        src: io
      }
      {
        name: io_div4
        aon: no
        freq: "24000000"
        ref: false
        div: "4"
        src: io
      }
    ]
    groups:
    [
      {
        name: ast
        src: ext
        sw_cg: no
        unique: no
        clocks: {}
      }
      {
        name: powerup
        src: top
        sw_cg: no
        unique: no
        clocks: {}
      }
      {
        name: trans
        src: top
        sw_cg: hint
        unique: yes
        clocks: {}
      }
      {
        name: infra
        src: top
        sw_cg: no
        unique: no
        clocks: {}
      }
      {
        name: secure
        src: top
        sw_cg: yes
        unique: no
        clocks: {}
      }
      {
        name: peri
        src: top
        sw_cg: yes
        unique: no
        clocks: {}
      }
    ]
  }
  resets:
  {
    hier_paths:
    {
      top: rstmgr_aon_resets.
      ext: ""
      lpg: rstmgr_aon_rst_en.
    }
    nodes:
    [
      {
        name: por_aon
        gen: false
        type: top
        domains: []
        shadowed: false
        sw: false
        path: rstmgr_aon_resets.rst_por_aon_n
        clock: aon
      }
      {
        name: lc_src
        gen: false
        type: int
        domains: []
        shadowed: false
        sw: false
        path: ""
        clock: io_div4
      }
      {
        name: sys_src
        gen: false
        type: int
        domains: []
        shadowed: false
        sw: false
        path: ""
        clock: io_div4
      }
      {
        name: por
        gen: true
        type: top
        domains: []
        shadowed: false
        sw: false
        path: rstmgr_aon_resets.rst_por_n
        parent: por_aon
        clock: main
      }
      {
        name: por_io
        gen: true
        type: top
        domains: []
        shadowed: false
        sw: false
        path: rstmgr_aon_resets.rst_por_io_n
        parent: por_aon
        clock: io
      }
      {
        name: por_io_div2
        gen: true
        type: top
        domains: []
        shadowed: false
        sw: false
        path: rstmgr_aon_resets.rst_por_io_div2_n
        parent: por_aon
        clock: io_div2
      }
      {
        name: por_io_div4
        gen: true
        type: top
        domains: []
        shadowed: false
        sw: false
        path: rstmgr_aon_resets.rst_por_io_div4_n
        parent: por_aon
        clock: io_div4
      }
      {
        name: por_usb
        gen: true
        type: top
        domains: []
        shadowed: false
        sw: false
        path: rstmgr_aon_resets.rst_por_usb_n
        parent: por_aon
        clock: usb
      }
      {
        name: lc
        gen: true
        type: top
        domains: []
        shadowed: false
        sw: false
        path: rstmgr_aon_resets.rst_lc_n
        parent: lc_src
        clock: main
      }
      {
        name: lc_aon
        gen: true
        type: top
        domains: []
        shadowed: false
        sw: false
        path: rstmgr_aon_resets.rst_lc_aon_n
        parent: lc_src
        clock: aon
      }
      {
        name: lc_io
        gen: true
        type: top
        domains: []
        shadowed: false
        sw: false
        path: rstmgr_aon_resets.rst_lc_io_n
        parent: lc_src
        clock: io
      }
      {
        name: lc_io_div2
        gen: true
        type: top
        domains: []
        shadowed: false
        sw: false
        path: rstmgr_aon_resets.rst_lc_io_div2_n
        parent: lc_src
        clock: io_div2
      }
      {
        name: lc_io_div4
        gen: true
        type: top
        domains: []
        shadowed: false
        sw: false
        path: rstmgr_aon_resets.rst_lc_io_div4_n
        parent: lc_src
        clock: io_div4
      }
      {
        name: lc_usb
        gen: true
        type: top
        domains: []
        shadowed: false
        sw: false
        path: rstmgr_aon_resets.rst_lc_usb_n
        parent: lc_src
        clock: usb
      }
      {
        name: sys
        gen: true
        type: top
        domains: []
        shadowed: false
        sw: true
        path: rstmgr_aon_resets.rst_sys_n
        parent: sys_src
        clock: main
      }
    ]
  }
  num_cores: "1"
  default_plic: rv_plic_mio
  addr_spaces:
  [
    {
      name: hart
      desc: The main address space, shared between the CPU and DM
      subspaces:
      [
        {
          name: mmio
          desc:
            '''
            MMIO region excludes any memory that is separate from the module configuration
            space, i.e. ROM, main SRAM, and mbx SRAM are excluded but retention SRAM or
            spi_device are included.
            '''
          nodes:
          [
            rv_timer
            aon_timer_aon
            sram_ctrl_ret_aon
            rv_plic_mio
            sram_ctrl_main.regs
            sram_ctrl_mbox.regs
            dma
            mbx0.core
            mbx1.core
            mbx2.core
            mbx3.core
            mbx4.core
            mbx5.core
            rv_core_ibex_mio
          ]
        }
      ]
    }
    {
      name: soc_mbx
      desc: SoC address space for mailbox access
    }
    {
      name: soc_dbg
      desc: SoC address space for debug module interfaces
    }
  ]
  module:
  [
    {
      name: rv_timer
      type: rv_timer
      clock_srcs:
      {
        clk_i: ext_io_div4
      }
      reset_connections:
      {
        rst_ni:
        {
          name: ext_rst_io_div4
          domain: "0"
        }
      }
      outgoing_alert: mio
      clock_group: secure
      clock_connections:
      {
        clk_i: clk_ext_io_div4_i
      }
      param_decl: {}
      memory: {}
      param_list: []
      inter_signal_list:
      [
        {
          name: racl_policies
          desc:
            '''
            Incoming RACL policy vector from a racl_ctrl instance.
            The policy selection vector (parameter) selects the policy for each register.
            '''
          struct: racl_policy_vec
          package: top_racl_pkg
          type: uni
          act: rcv
          width: 1
          inst_name: rv_timer
          default: ""
          top_signame: racl_ctrl_mio_racl_policies
          index: -1
        }
        {
          name: racl_error
          desc: RACL error log information of this module.
          struct: racl_error_log
          package: top_racl_pkg
          type: uni
          act: req
          width: 1
          inst_name: rv_timer
          default: ""
          top_signame: racl_ctrl_mio_racl_error
          index: 0
        }
        {
          name: tl
          struct: tl
          package: tlul_pkg
          type: req_rsp
          act: rsp
          width: 1
          inst_name: rv_timer
          default: ""
          end_idx: -1
          top_signame: rv_timer_tl
          index: -1
        }
      ]
      base_addrs:
      {
        null:
        {
          hart: 0x30000000
        }
      }
      generate_dif: true
      racl_mappings:
      {
        null:
        {
          racl_group: mio
          register_mapping:
          {
            ALERT_TEST: 6
            CTRL: 0
            INTR_ENABLE0: 0
            INTR_STATE0: 0
            INTR_TEST0: 0
            CFG0: 0
            TIMER_V_LOWER0: 0
            TIMER_V_UPPER0: 0
            COMPARE_LOWER0_0: 0
            COMPARE_UPPER0_0: 0
          }
          window_mapping: {}
          range_mapping: []
        }
      }
      domain:
      [
        "0"
      ]
    }
    {
      name: aon_timer_aon
      type: aon_timer
      clock_srcs:
      {
        clk_i: ext_io_div4
        clk_aon_i: ext_aon
      }
      reset_connections:
      {
        rst_ni:
        {
          name: ext_rst_io_div4
          domain: "0"
        }
        rst_aon_ni:
        {
          name: ext_rst_aon
          domain: "0"
        }
      }
      domain:
      [
        "0"
      ]
      outgoing_alert: mio
      clock_group: secure
      clock_connections:
      {
        clk_i: clk_ext_io_div4_i
        clk_aon_i: clk_ext_aon_i
      }
      param_decl: {}
      memory: {}
      param_list: []
      inter_signal_list:
      [
        {
          name: nmi_wdog_timer_bark
          struct: logic
          type: uni
          act: req
          width: 1
          default: 1'b0
          inst_name: aon_timer_aon
          package: ""
          end_idx: -1
          top_type: broadcast
          top_signame: aon_timer_aon_nmi_wdog_timer_bark
          index: -1
        }
        {
          name: wkup_req
          struct: logic
          type: uni
          act: req
          width: 1
          default: 1'b0
          inst_name: aon_timer_aon
          index: -1
        }
        {
          name: aon_timer_rst_req
          struct: logic
          type: uni
          act: req
          width: 1
          default: 1'b0
          inst_name: aon_timer_aon
          package: ""
          external: true
          top_signame: aon_timer_rst_req
          conn_type: false
          index: -1
        }
        {
          name: lc_escalate_en
          struct: lc_tx
          package: lc_ctrl_pkg
          type: uni
          act: rcv
          width: 1
          default: lc_ctrl_pkg::Off
          inst_name: aon_timer_aon
          top_signame: mio_soc_proxy_lc_escalate_en
          index: -1
        }
        {
          name: sleep_mode
          struct: logic
          type: uni
          act: rcv
          width: 1
          inst_name: aon_timer_aon
          index: -1
        }
        {
          name: racl_policies
          desc:
            '''
            Incoming RACL policy vector from a racl_ctrl instance.
            The policy selection vector (parameter) selects the policy for each register.
            '''
          struct: racl_policy_vec
          package: top_racl_pkg
          type: uni
          act: rcv
          width: 1
          inst_name: aon_timer_aon
          default: ""
          top_signame: racl_ctrl_mio_racl_policies
          index: -1
        }
        {
          name: racl_error
          desc: RACL error log information of this module.
          struct: racl_error_log
          package: top_racl_pkg
          type: uni
          act: req
          width: 1
          inst_name: aon_timer_aon
          default: ""
          top_signame: racl_ctrl_mio_racl_error
          index: 1
        }
        {
          name: tl
          struct: tl
          package: tlul_pkg
          type: req_rsp
          act: rsp
          width: 1
          inst_name: aon_timer_aon
          default: ""
          end_idx: -1
          top_signame: aon_timer_aon_tl
          index: -1
        }
      ]
      base_addrs:
      {
        null:
        {
          hart: 0x30470000
        }
      }
      generate_dif: true
      racl_mappings:
      {
        null:
        {
          racl_group: mio
          register_mapping:
          {
            ALERT_TEST: 6
            WKUP_CTRL: 0
            WKUP_THOLD_HI: 0
            WKUP_THOLD_LO: 0
            WKUP_COUNT_HI: 0
            WKUP_COUNT_LO: 0
            WDOG_REGWEN: 0
            WDOG_CTRL: 0
            WDOG_BARK_THOLD: 0
            WDOG_BITE_THOLD: 0
            WDOG_COUNT: 0
            INTR_STATE: 0
            INTR_TEST: 0
            WKUP_CAUSE: 0
          }
          window_mapping: {}
          range_mapping: []
        }
      }
    }
    {
      name: mio_soc_proxy
      type: mio_soc_proxy
      clock_srcs:
      {
        clk_i: ext_main
      }
      reset_connections:
      {
        rst_ni:
        {
          name: ext_rst_main
          domain: "0"
        }
      }
      domain:
      [
        "0"
      ]
      base_addrs:
      {
        ctn:
        {
          hart: 0x40000000
        }
      }
      attr: reggen_top
      memory:
      {
        ctn:
        {
          label: ctn
          swaccess: rw
          data_intg_passthru: "true"
          exec: True
          byte_write: True
          size: 0x80000000
        }
      }
      outgoing_alert: mio
      clock_group: secure
      clock_connections:
      {
        clk_i: clk_ext_main_i
      }
      param_decl: {}
      param_list: []
      inter_signal_list:
      [
        {
          name: lc_escalate_en
          desc:
            '''
            Escalation enable signal coming from life cycle controller, used for invalidating
            the latched lc_hw_debug_en state inside the strap sampling logic.
            '''
          struct: lc_tx
          package: lc_ctrl_pkg
          type: uni
          act: req
          width: 1
          default: lc_ctrl_pkg::Off
          inst_name: mio_soc_proxy
          end_idx: -1
          top_type: broadcast
          top_signame: mio_soc_proxy_lc_escalate_en
          index: -1
        }
        {
          name: lc_escalate_en_ext
          desc:
            '''
            Escalation enable signal coming from life cycle controller, used for invalidating
            the latched lc_hw_debug_en state inside the strap sampling logic.
            '''
          struct: lc_tx
          package: lc_ctrl_pkg
          type: uni
          act: rcv
          width: 1
          default: lc_ctrl_pkg::Off
          inst_name: mio_soc_proxy
          external: true
          top_signame: lc_escalate_en_ext
          conn_type: false
          index: -1
        }
        {
          name: lc_hw_debug_en
          desc:
            '''
            Multibit life cycle hardware debug enable signal coming from life cycle controller,
            asserted when the hardware debug mechanisms are enabled in the system.
            '''
          struct: lc_tx
          package: lc_ctrl_pkg
          type: uni
          act: req
          width: 1
          default: lc_ctrl_pkg::Off
          inst_name: mio_soc_proxy
          end_idx: -1
          top_type: broadcast
          top_signame: mio_soc_proxy_lc_hw_debug_en
          index: -1
        }
        {
          name: lc_hw_debug_en_ext
          desc:
            '''
            Multibit life cycle hardware debug enable signal coming from life cycle controller,
            asserted when the hardware debug mechanisms are enabled in the system.
            '''
          struct: lc_tx
          package: lc_ctrl_pkg
          type: uni
          act: rcv
          width: 1
          default: lc_ctrl_pkg::Off
          inst_name: mio_soc_proxy
          external: true
          top_signame: lc_hw_debug_en_ext
          conn_type: false
          index: -1
        }
        {
          name: dma_tl_h2d
          desc: TL-UL host port for the DMA to egress into CTN (request part), synchronous
          struct: tl_h2d
          package: tlul_pkg
          type: uni
          act: rcv
          width: 1
          inst_name: mio_soc_proxy
          default: ""
          end_idx: -1
          top_type: broadcast
          top_signame: mio_soc_proxy_dma_tl_h2d
          index: -1
        }
        {
          name: dma_tl_d2h
          desc: TL-UL host port for the DMA to egress into CTN (response part), synchronous
          struct: tl_d2h
          package: tlul_pkg
          type: uni
          act: req
          width: 1
          inst_name: mio_soc_proxy
          default: ""
          end_idx: -1
          top_type: broadcast
          top_signame: mio_soc_proxy_dma_tl_d2h
          index: -1
        }
        {
          name: muxed_tl_h2d
          desc: Muxed TL-UL host port to go into AC ranges (request part), synchronous
          struct: tl_h2d
          package: tlul_pkg
          type: uni
          act: req
          width: 1
          inst_name: mio_soc_proxy
          default: ""
          end_idx: -1
          top_type: broadcast
          top_signame: mio_soc_proxy_muxed_tl_h2d
          index: -1
        }
        {
          name: muxed_tl_d2h
          desc: Muxed TL-UL host port to go into AC ranges (response part), synchronous
          struct: tl_d2h
          package: tlul_pkg
          type: uni
          act: rcv
          width: 1
          inst_name: mio_soc_proxy
          default: ""
          end_idx: -1
          top_type: broadcast
          top_signame: mio_soc_proxy_muxed_tl_d2h
          index: -1
        }
        {
          name: ac_range_tl_h2d
          desc: TL-UL host port from the AC range, through BAT, to CTN (request part), synchronous
          struct: tl_h2d
          package: tlul_pkg
          type: uni
          act: rcv
          width: 1
          inst_name: mio_soc_proxy
          default: ""
          top_signame: ac_range_check_mio_ctn_filtered_tl_h2d
          index: -1
        }
        {
          name: ac_range_tl_d2h
          desc: TL-UL host port from the AC range, through BAT, to CTN(response part), synchronous
          struct: tl_d2h
          package: tlul_pkg
          type: uni
          act: req
          width: 1
          inst_name: mio_soc_proxy
          default: ""
          top_signame: ac_range_check_mio_ctn_filtered_tl_d2h
          index: -1
        }
        {
          name: ctn_tl_h2d
          desc: TL-UL host port for egress into CTN (request part), synchronous
          struct: tl_h2d
          package: tlul_pkg
          type: uni
          act: req
          width: 1
          inst_name: mio_soc_proxy
          default: ""
          external: true
          top_signame: ctn_tl_h2d
          conn_type: false
          index: -1
        }
        {
          name: ctn_tl_d2h
          desc: TL-UL host port for egress into CTN (response part), synchronous
          struct: tl_d2h
          package: tlul_pkg
          type: uni
          act: rcv
          width: 1
          inst_name: mio_soc_proxy
          default: ""
          external: true
          top_signame: ctn_tl_d2h
          conn_type: false
          index: -1
        }
        {
          name: soc_lsio_trigger
          desc: LSIO trigger signal from SoC, synchronous
          struct: logic
          type: uni
          act: rcv
          width: 8
          inst_name: mio_soc_proxy
          default: ""
          package: ""
          external: true
          top_signame: soc_lsio_trigger
          conn_type: false
          index: -1
        }
        {
          name: dma_lsio_trigger
          desc: Collated synchronous LSIO trigger signals for DMA
          struct: lsio_trigger
          package: dma_pkg
          type: uni
          act: req
          width: 1
          inst_name: mio_soc_proxy
          default: ""
          top_signame: dma_lsio_trigger
          index: -1
        }
        {
          name: integrator_id
          desc: Integrator ID signal used in BAT
          struct: logic
          type: uni
          act: rcv
          width: 4
          inst_name: mio_soc_proxy
          default: ""
          package: ""
          external: true
          top_signame: integrator_id
          conn_type: false
          index: -1
        }
        {
          name: mubi8_true
          struct: mubi8
          package: prim_mubi_pkg
          type: uni
          act: req
          width: 1
          default: prim_mubi_pkg::MuBi8False
          inst_name: mio_soc_proxy
          top_signame: sram_ctrl_main_otp_en_sram_ifetch
          index: -1
        }
        {
          name: ctn_tl
          struct: tl
          package: tlul_pkg
          type: req_rsp
          act: rsp
          width: 1
          inst_name: mio_soc_proxy
          default: ""
          end_idx: -1
          top_signame: mio_soc_proxy_ctn_tl
          index: -1
        }
      ]
      generate_dif: true
    }
    {
      name: sram_ctrl_ret_aon
      type: sram_ctrl
      clock_srcs:
      {
        clk_i: ext_io_div4
        clk_otp_i: ext_io_div4
      }
      clock_group: infra
      reset_connections:
      {
        rst_ni:
        {
          name: ext_rst_io_div4
          domain: "0"
        }
        rst_otp_ni:
        {
          name: ext_rst_io_div4
          domain: "0"
        }
      }
      domain:
      [
        "0"
      ]
      param_decl:
      {
        InstrExec: "0"
        InstSize: 4096
        FlopRamOutput: 1
        EccCorrection: 1
        Outstanding: 6
      }
      base_addrs:
      {
        regs:
        {
          hart: 0x30500000
        }
        ram:
        {
          hart: 0x30600000
        }
      }
      memory:
      {
        ram:
        {
          label: ram_ret_aon
          swaccess: rw
          data_intg_passthru: "true"
          exec: True
          byte_write: True
          size: 0x1000
        }
      }
      outgoing_alert: mio
      racl_mappings:
      {
        regs:
        {
          racl_group: mio
          register_mapping:
          {
            ALERT_TEST: 6
            STATUS: 0
            EXEC_REGWEN: 0
            EXEC: 0
            CTRL_REGWEN: 0
            CTRL: 0
            SCR_KEY_ROTATED: 0
            READBACK_REGWEN: 0
            READBACK: 0
          }
          window_mapping: {}
          range_mapping: []
        }
      }
      clock_connections:
      {
        clk_i: clk_ext_io_div4_i
        clk_otp_i: clk_ext_io_div4_i
      }
      param_list:
      [
        {
          name: MemSizeRam
          desc: Memory size of the RAM (in bytes).
          type: int
          name_top: MemSizeSramCtrlRetAonRam
          default: 4096
        }
        {
          name: InstSize
          desc: Memory size of a single RAM tile (in bytes).
          type: int
          default: 4096
          local: "false"
          expose: "true"
          name_top: SramCtrlRetAonInstSize
        }
        {
          name: NumRamInst
          desc: Number of internal RAM instances. Must be the same as ceil(MemSizeRam / InstSize) .
          type: int
          default: 1
          local: "false"
          expose: "true"
          name_top: SramCtrlRetAonNumRamInst
        }
        {
          name: InstrExec
          desc: Support execution from SRAM
          type: bit
          default: "0"
          local: "false"
          expose: "true"
          name_top: SramCtrlRetAonInstrExec
        }
        {
          name: NumPrinceRoundsHalf
          desc: Number of PRINCE half rounds for the SRAM scrambling feature
          type: int
          default: "3"
          local: "false"
          expose: "true"
          name_top: SramCtrlRetAonNumPrinceRoundsHalf
        }
        {
          name: Outstanding
          desc: Number of outstanding TLUL transactions
          type: int
          default: 6
          local: "true"
          expose: "true"
          name_top: SramCtrlRetAonOutstanding
        }
        {
          name: EccCorrection
          desc: Enable single-bit error correction and error logging
          type: bit
          default: 1
          local: "false"
          expose: "true"
          name_top: SramCtrlRetAonEccCorrection
        }
        {
          name: FlopRamOutput
          desc: Add a flop stage after the RAM macro output.
          type: bit
          default: 1
          local: "false"
          expose: "true"
          name_top: SramCtrlRetAonFlopRamOutput
        }
        {
          name: FlopWdataScramble
          desc: Add a flop stage after the write data scrambler.
          type: bit
          default: "0"
          local: "false"
          expose: "true"
          name_top: SramCtrlRetAonFlopWdataScramble
        }
        {
          name: FlopReadAddrScramble
          desc: Add a flop stage after the address scrambler for reads.
          type: bit
          default: "0"
          local: "false"
          expose: "true"
          name_top: SramCtrlRetAonFlopReadAddrScramble
        }
        {
          name: FlopEccOutput
          desc: Add a flop stage after the ECC output.
          type: bit
          default: "0"
          local: "true"
          expose: "true"
          name_top: SramCtrlRetAonFlopEccOutput
        }
      ]
      inter_signal_list:
      [
        {
          name: sram_otp_key
          struct: sram_otp_key
          package: otp_ctrl_pkg
          type: req_rsp
          act: req
          width: 1
          inst_name: sram_ctrl_ret_aon
          index: -1
        }
        {
          name: cfg
          struct: ram_1p_cfg
          package: prim_ram_1p_pkg
          type: uni
          act: rcv
          width:
          {
            name: NumRamInst
            desc: Number of internal RAM instances. Must be the same as ceil(MemSizeRam / InstSize) .
            param_type: int
            unpacked_dimensions: null
            default: 1
            local: false
            expose: true
            name_top: SramCtrlRetAonNumRamInst
          }
          default: "'0"
          inst_name: sram_ctrl_ret_aon
          external: true
          top_signame: sram_ctrl_ret_aon_ram_1p_cfg
          conn_type: false
          index: -1
        }
        {
          name: cfg_rsp
          struct: ram_1p_cfg_rsp
          package: prim_ram_1p_pkg
          type: uni
          act: req
          width:
          {
            name: NumRamInst
            desc: Number of internal RAM instances. Must be the same as ceil(MemSizeRam / InstSize) .
            param_type: int
            unpacked_dimensions: null
            default: 1
            local: false
            expose: true
            name_top: SramCtrlRetAonNumRamInst
          }
          default: "'0"
          inst_name: sram_ctrl_ret_aon
          external: true
          top_signame: sram_ctrl_ret_aon_ram_1p_cfg_rsp
          conn_type: false
          index: -1
        }
        {
          name: lc_escalate_en
          struct: lc_tx
          package: lc_ctrl_pkg
          type: uni
          act: rcv
          width: 1
          default: lc_ctrl_pkg::Off
          inst_name: sram_ctrl_ret_aon
          top_signame: mio_soc_proxy_lc_escalate_en
          index: -1
        }
        {
          name: lc_hw_debug_en
          struct: lc_tx
          package: lc_ctrl_pkg
          type: uni
          act: rcv
          width: 1
          default: lc_ctrl_pkg::Off
          inst_name: sram_ctrl_ret_aon
          top_signame: mio_soc_proxy_lc_hw_debug_en
          index: -1
        }
        {
          name: otp_en_sram_ifetch
          struct: mubi8
          package: prim_mubi_pkg
          type: uni
          act: rcv
          width: 1
          default: prim_mubi_pkg::MuBi8False
          inst_name: sram_ctrl_ret_aon
          index: -1
        }
        {
          name: racl_policies
          desc:
            '''
            Incoming RACL policy vector from a racl_ctrl instance.
            The policy selection vector (parameter) selects the policy for each register.
            '''
          struct: racl_policy_vec
          package: top_racl_pkg
          type: uni
          act: rcv
          width: 1
          inst_name: sram_ctrl_ret_aon
          default: ""
          top_signame: racl_ctrl_mio_racl_policies
          index: -1
        }
        {
          name: racl_error
          desc: RACL error log information of this module.
          struct: racl_error_log
          package: top_racl_pkg
          type: uni
          act: req
          width: 1
          inst_name: sram_ctrl_ret_aon
          default: ""
          top_signame: racl_ctrl_mio_racl_error
          index: 2
        }
        {
          name: sram_rerror
          desc: SRAM read error indicating correctable and uncorrectable ECC errors.
          struct: sram_error_t
          package: sram_ctrl_pkg
          type: uni
          act: req
          width: 1
          inst_name: sram_ctrl_ret_aon
          index: -1
        }
        {
          name: regs_tl
          struct: tl
          package: tlul_pkg
          type: req_rsp
          act: rsp
          width: 1
          inst_name: sram_ctrl_ret_aon
          default: ""
          end_idx: -1
          top_signame: sram_ctrl_ret_aon_regs_tl
          index: -1
        }
        {
          name: ram_tl
          struct: tl
          package: tlul_pkg
          type: req_rsp
          act: rsp
          width: 1
          inst_name: sram_ctrl_ret_aon
          default: ""
          end_idx: -1
          top_signame: sram_ctrl_ret_aon_ram_tl
          index: -1
        }
      ]
      generate_dif: true
    }
    {
      name: rv_dm
      type: rv_dm
      clock_srcs:
      {
        clk_i: ext_main
        clk_lc_i: ext_main
      }
      reset_connections:
      {
        rst_ni:
        {
          name: ext_rst_main
          domain: "0"
        }
        rst_lc_ni:
        {
          name: ext_rst_main
          domain: "0"
        }
      }
      base_addrs:
      {
        mem:
        {
          hart: 0x00040000
        }
        regs:
        {
          hart: 0x21200000
        }
        dbg:
        {
          soc_dbg: 0x00000000
        }
      }
      param_decl:
      {
        SecVolatileRawUnlockEn: top_pkg::SecVolatileRawUnlockEn
        UseDmiInterface: "1"
      }
      generate_dif: false
      outgoing_alert: mio
      racl_mappings:
      {
        regs:
        {
          racl_group: mio
          register_mapping:
          {
            ALERT_TEST: 6
            LATE_DEBUG_ENABLE_REGWEN: 0
            LATE_DEBUG_ENABLE: 0
          }
          window_mapping: {}
          range_mapping: []
        }
      }
      clock_group: secure
      clock_connections:
      {
        clk_i: clk_ext_main_i
        clk_lc_i: clk_ext_main_i
      }
      memory: {}
      param_list:
      [
        {
          name: IdcodeValue
          desc: RISC-V debug module JTAG ID code.
          type: logic [31:0]
          default: 32'h 0000_0001
          local: "false"
          expose: "true"
          name_top: RvDmIdcodeValue
        }
        {
          name: UseDmiInterface
          desc: When 1, a TLUL-based DMI interface is used. When 0, a JTAG TAP is used.
          type: bit
          default: "1"
          local: "false"
          expose: "true"
          name_top: RvDmUseDmiInterface
        }
        {
          name: SecVolatileRawUnlockEn
          desc:
            '''
            Disable (0) or enable (1) volatile RAW UNLOCK capability.
            If enabled, the strap_en_override_i input can be used to re-sample the straps at runtime.
            IMPORTANT NOTE: This should only be used in test chips. The parameter must be set
            to 0 in production tapeouts since this weakens the security posture of the RAW
            UNLOCK mechanism.
            '''
          type: bit
          default: top_pkg::SecVolatileRawUnlockEn
          local: "false"
          expose: "true"
          name_top: SecRvDmVolatileRawUnlockEn
        }
        {
          name: TlulHostUserRsvdBits
          desc: TLUL user bits sent on outgoing transfers.
          type: logic [tlul_pkg::RsvdWidth-1:0]
          default: "'0"
          local: "false"
          expose: "true"
          name_top: RvDmTlulHostUserRsvdBits
        }
      ]
      inter_signal_list:
      [
        {
          name: next_dm_addr
          desc:
            '''
            32bit word address of the next debug module.
            Set to 0x0 if this is the last debug module in the chain.
            '''
          struct: next_dm_addr
          package: rv_dm_pkg
          type: uni
          act: rcv
          width: 1
          default: "'0"
          inst_name: rv_dm
          external: true
          top_signame: rv_dm_next_dm_addr
          conn_type: false
          index: -1
        }
        {
          name: jtag
          desc: JTAG signals for the RISC-V TAP.
          struct: jtag
          package: jtag_pkg
          type: req_rsp
          act: rsp
          width: 1
          inst_name: rv_dm
          index: -1
        }
        {
          name: lc_init_done
          desc: Lifecycle initialization done signal coming from life cycle controller.
          struct: lc_tx
          package: lc_ctrl_pkg
          type: uni
          act: rcv
          width: 1
          default: lc_ctrl_pkg::Off
          inst_name: rv_dm
          index: -1
        }
        {
          name: lc_hw_debug_clr
          desc:
            '''
            Multibit life cycle hardware debug clear signal coming from life cycle controller,
            asserted when the hardware debug mechanism was enabled and gets disabled.
            '''
          struct: lc_tx
          package: lc_ctrl_pkg
          type: uni
          act: rcv
          width: 1
          default: lc_ctrl_pkg::Off
          inst_name: rv_dm
          index: -1
        }
        {
          name: lc_hw_debug_en
          desc:
            '''
            Multibit life cycle hardware debug enable signal coming from life cycle controller,
            asserted when the hardware debug mechanisms are enabled in the system.
            '''
          struct: lc_tx
          package: lc_ctrl_pkg
          type: uni
          act: rcv
          width: 1
          default: lc_ctrl_pkg::Off
          inst_name: rv_dm
          top_signame: mio_soc_proxy_lc_hw_debug_en
          index: -1
        }
        {
          name: lc_dft_en
          desc:
            '''
            Multibit life cycle hardware debug enable signal coming from life cycle controller,
            asserted when the DFT mechanisms are enabled in the system.
            '''
          struct: lc_tx
          package: lc_ctrl_pkg
          type: uni
          act: rcv
          width: 1
          default: lc_ctrl_pkg::Off
          inst_name: rv_dm
          index: -1
        }
        {
          name: pinmux_hw_debug_en
          desc:
            '''
            Multibit life cycle hardware debug enable signal coming from pinmux.
            This is a latched version of the lc_hw_debug_en signal and is only used to
            gate the JTAG / TAP side of the RV_DM. It is used to keep a debug session live
            while the rest of the system undergoes an NDM reset.
            '''
          struct: lc_tx
          package: lc_ctrl_pkg
          type: uni
          act: rcv
          width: 1
          default: lc_ctrl_pkg::Off
          inst_name: rv_dm
          index: -1
        }
        {
          name: otp_dis_rv_dm_late_debug
          struct: mubi8
          package: prim_mubi_pkg
          type: uni
          act: rcv
          width: 1
          default: prim_mubi_pkg::MuBi8False
          inst_name: rv_dm
          top_signame: rv_dm_otp_dis_rv_dm_late_debug
          index: -1
        }
        {
          name: unavailable
          desc:
            '''
            This signal indicates to the debug module that the main processor is not available
            for debug (e.g. due to a low-power state).
            '''
          struct: logic
          type: uni
          act: rcv
          width: 1
          default: 1'b0
          inst_name: rv_dm
          index: -1
        }
        {
          name: ndmreset_req
          desc: Non-debug module reset request going to the system reset infrastructure.
          struct: logic
          type: uni
          act: req
          width: 1
          inst_name: rv_dm
          index: -1
        }
        {
          name: dmactive
          desc:
            '''
            This signal indicates whether the debug module is active and can be used to prevent
            power down of the core and bus-attached peripherals.
            '''
          struct: logic
          type: uni
          act: req
          width: 1
          inst_name: rv_dm
          index: -1
        }
        {
          name: debug_req
          desc: This is the debug request interrupt going to the main processor.
          struct: logic [rv_dm_reg_pkg::NrHarts-1:0]
          type: uni
          act: req
          width: 1
          inst_name: rv_dm
          default: ""
          package: ""
          end_idx: -1
          top_type: broadcast
          top_signame: rv_dm_debug_req
          index: -1
        }
        {
          name: lc_escalate_en
          desc:
            '''
            Escalation enable signal coming from life cycle controller, used for invalidating
            the latched lc_hw_debug_en state inside the strap sampling logic.
            '''
          struct: lc_tx
          package: lc_ctrl_pkg
          type: uni
          act: rcv
          width: 1
          default: lc_ctrl_pkg::Off
          inst_name: rv_dm
          top_signame: mio_soc_proxy_lc_escalate_en
          index: -1
        }
        {
          name: lc_check_byp_en
          desc:
            '''
            Check bypass enable signal coming from life cycle controller, used for invalidating
            the latched lc_hw_debug_en state inside the strap sampling logic. This signal is asserted
            whenever the life cycle controller performs a life cycle transition. Its main use is
            to skip any background checks inside the life cycle partition of the OTP controller while
            a life cycle transition is in progress.
            '''
          struct: lc_tx
          package: lc_ctrl_pkg
          type: uni
          act: rcv
          width: 1
          default: lc_ctrl_pkg::Off
          inst_name: rv_dm
          external: true
          top_signame: lc_check_byp_en
          conn_type: false
          index: -1
        }
        {
          name: strap_en
          desc: This signal is pulsed high by the power manager after reset in order to sample the HW straps.
          struct: logic
          type: uni
          act: rcv
          width: 1
          default: 1'b0
          inst_name: rv_dm
          package: ""
          external: true
          top_signame: rv_dm_strap_en
          conn_type: false
          index: -1
        }
        {
          name: strap_en_override
          desc:
            '''
            This signal transitions from 0 -> 1 by the lc_ctrl manager after volatile RAW_UNLOCK in order to re-sample the HW straps.
            The signal must stay at 1 until reset.
            Note that this is only used in test chips when SecVolatileRawUnlockEn = 1.
            Otherwise this signal is unused.
            '''
          struct: logic
          type: uni
          act: rcv
          width: 1
          default: 1'b0
          inst_name: rv_dm
          package: ""
          external: true
          top_signame: rv_dm_strap_en_override
          conn_type: false
          index: -1
        }
        {
          name: racl_policies
          desc:
            '''
            Incoming RACL policy vector from a racl_ctrl instance.
            The policy selection vector (parameter) selects the policy for each register.
            '''
          struct: racl_policy_vec
          package: top_racl_pkg
          type: uni
          act: rcv
          width: 1
          inst_name: rv_dm
          default: ""
          top_signame: racl_ctrl_mio_racl_policies
          index: -1
        }
        {
          name: racl_error
          desc: RACL error log information of this module.
          struct: racl_error_log
          package: top_racl_pkg
          type: uni
          act: req
          width: 1
          inst_name: rv_dm
          default: ""
          top_signame: racl_ctrl_mio_racl_error
          index: 3
        }
        {
          name: sba_tl_h
          struct: tl
          package: tlul_pkg
          type: req_rsp
          act: req
          width: 1
          inst_name: rv_dm
          default: ""
          top_signame: mio_main_tl_rv_dm__sba
          index: -1
        }
        {
          name: regs_tl_d
          struct: tl
          package: tlul_pkg
          type: req_rsp
          act: rsp
          width: 1
          inst_name: rv_dm
          default: ""
          end_idx: -1
          top_signame: rv_dm_regs_tl_d
          index: -1
        }
        {
          name: mem_tl_d
          struct: tl
          package: tlul_pkg
          type: req_rsp
          act: rsp
          width: 1
          inst_name: rv_dm
          default: ""
          end_idx: -1
          top_signame: rv_dm_mem_tl_d
          index: -1
        }
        {
          name: dbg_tl_d
          struct: tl
          package: tlul_pkg
          type: req_rsp
          act: rsp
          width: 1
          inst_name: rv_dm
          default: ""
          external: true
          top_signame: rv_dm_dbg
          conn_type: false
          index: -1
        }
      ]
      domain:
      [
        "0"
      ]
    }
    {
      name: rv_plic_mio
      type: rv_plic_mio
      template_type: rv_plic
      ipgen_params:
      {
        racl_support: true
      }
      clock_srcs:
      {
        clk_i: ext_main
      }
      clock_group: secure
      reset_connections:
      {
        rst_ni:
        {
          name: ext_rst_main
          domain: "0"
        }
      }
      attr: ipgen
      outgoing_alert: mio
      incoming_interrupt:
      [
        mio_external_irq_cfg.hjson
      ]
      targets:
      [
        rv_core_ibex_mio
      ]
      clock_connections:
      {
        clk_i: clk_ext_main_i
      }
      param_decl: {}
      memory: {}
      param_list: []
      inter_signal_list:
      [
        {
          name: irq
          struct: logic
          type: uni
          act: req
          width: 1
          inst_name: rv_plic_mio
          default: ""
          package: ""
          end_idx: -1
          top_type: broadcast
          top_signame: rv_plic_mio_irq
          index: -1
        }
        {
          name: irq_id
          struct: logic
          type: uni
          act: req
          width: 1
          inst_name: rv_plic_mio
          index: -1
        }
        {
          name: msip
          struct: logic
          type: uni
          act: req
          width: 1
          inst_name: rv_plic_mio
          default: ""
          package: ""
          end_idx: -1
          top_type: broadcast
          top_signame: rv_plic_mio_msip
          index: -1
        }
        {
          name: racl_policies
          desc:
            '''
            Incoming RACL policy vector from a racl_ctrl instance.
            The policy selection vector (parameter) selects the policy for each register.
            '''
          struct: racl_policy_vec
          package: top_racl_pkg
          type: uni
          act: rcv
          width: 1
          inst_name: rv_plic_mio
          default: ""
          top_signame: racl_ctrl_mio_racl_policies
          index: -1
        }
        {
          name: racl_error
          desc: RACL error log information of this module.
          struct: racl_error_log
          package: top_racl_pkg
          type: uni
          act: req
          width: 1
          inst_name: rv_plic_mio
          default: ""
          top_signame: racl_ctrl_mio_racl_error
          index: 4
        }
        {
          name: tl
          struct: tl
          package: tlul_pkg
          type: req_rsp
          act: rsp
          width: 1
          inst_name: rv_plic_mio
          default: ""
          end_idx: -1
          top_signame: rv_plic_mio_tl
          index: -1
        }
      ]
      base_addrs:
      {
        null:
        {
          hart: 0x28000000
        }
      }
      generate_dif: true
      racl_mappings:
      {
        null:
        {
          racl_group: mio
          register_mapping:
          {
            PRIO_0: 0
            PRIO_1: 0
            PRIO_2: 0
            PRIO_3: 0
            PRIO_4: 0
            PRIO_5: 0
            PRIO_6: 0
            PRIO_7: 0
            PRIO_8: 0
            PRIO_9: 0
            PRIO_10: 0
            PRIO_11: 0
            PRIO_12: 0
            PRIO_13: 0
            PRIO_14: 0
            PRIO_15: 0
            PRIO_16: 0
            PRIO_17: 0
            PRIO_18: 0
            PRIO_19: 0
            PRIO_20: 0
            PRIO_21: 0
            PRIO_22: 0
            PRIO_23: 0
            PRIO_24: 0
            PRIO_25: 0
            PRIO_26: 0
            PRIO_27: 0
            PRIO_28: 0
            PRIO_29: 0
            PRIO_30: 0
            PRIO_31: 0
            PRIO_32: 0
            PRIO_33: 0
            PRIO_34: 0
            PRIO_35: 0
            PRIO_36: 0
            IP_0: 0
            IP_1: 0
            IE0_0: 0
            IE0_1: 0
            THRESHOLD0: 0
            CC0: 0
            MSIP0: 0
            ALERT_TEST: 6
          }
          window_mapping: {}
          range_mapping: []
        }
      }
      domain:
      [
        "0"
      ]
    }
    {
      name: sram_ctrl_main
      type: sram_ctrl
      clock_srcs:
      {
        clk_i: ext_main
        clk_otp_i: ext_io_div4
      }
      clock_group: infra
      reset_connections:
      {
        rst_ni:
        {
          name: ext_rst_main
          domain: "0"
        }
        rst_otp_ni:
        {
          name: ext_rst_io_div4
          domain: "0"
        }
      }
      param_decl:
      {
        InstrExec: "1"
        InstSize: 32768
        NumRamInst: 2
        FlopRamOutput: 1
        EccCorrection: 1
        FlopWdataScramble: 1
        FlopReadAddrScramble: 1
        Outstanding: 6
      }
      base_addrs:
      {
        regs:
        {
          hart: 0x211c0000
        }
        ram:
        {
          hart: 0x10000000
        }
      }
      memory:
      {
        ram:
        {
          label: ram_main
          swaccess: rw
          data_intg_passthru: "true"
          exec: True
          byte_write: True
          size: 0x10000
        }
      }
      outgoing_alert: mio
      racl_mappings:
      {
        regs:
        {
          racl_group: mio
          register_mapping:
          {
            ALERT_TEST: 6
            STATUS: 0
            EXEC_REGWEN: 0
            EXEC: 0
            CTRL_REGWEN: 0
            CTRL: 0
            SCR_KEY_ROTATED: 0
            READBACK_REGWEN: 0
            READBACK: 0
          }
          window_mapping: {}
          range_mapping: []
        }
      }
      clock_connections:
      {
        clk_i: clk_ext_main_i
        clk_otp_i: clk_ext_io_div4_i
      }
      param_list:
      [
        {
          name: MemSizeRam
          desc: Memory size of the RAM (in bytes).
          type: int
          name_top: MemSizeSramCtrlMainRam
          default: 65536
        }
        {
          name: InstSize
          desc: Memory size of a single RAM tile (in bytes).
          type: int
          default: 32768
          local: "false"
          expose: "true"
          name_top: SramCtrlMainInstSize
        }
        {
          name: NumRamInst
          desc: Number of internal RAM instances. Must be the same as ceil(MemSizeRam / InstSize) .
          type: int
          default: 2
          local: "false"
          expose: "true"
          name_top: SramCtrlMainNumRamInst
        }
        {
          name: InstrExec
          desc: Support execution from SRAM
          type: bit
          default: "1"
          local: "false"
          expose: "true"
          name_top: SramCtrlMainInstrExec
        }
        {
          name: NumPrinceRoundsHalf
          desc: Number of PRINCE half rounds for the SRAM scrambling feature
          type: int
          default: "3"
          local: "false"
          expose: "true"
          name_top: SramCtrlMainNumPrinceRoundsHalf
        }
        {
          name: Outstanding
          desc: Number of outstanding TLUL transactions
          type: int
          default: 6
          local: "true"
          expose: "true"
          name_top: SramCtrlMainOutstanding
        }
        {
          name: EccCorrection
          desc: Enable single-bit error correction and error logging
          type: bit
          default: 1
          local: "false"
          expose: "true"
          name_top: SramCtrlMainEccCorrection
        }
        {
          name: FlopRamOutput
          desc: Add a flop stage after the RAM macro output.
          type: bit
          default: 1
          local: "false"
          expose: "true"
          name_top: SramCtrlMainFlopRamOutput
        }
        {
          name: FlopWdataScramble
          desc: Add a flop stage after the write data scrambler.
          type: bit
          default: 1
          local: "false"
          expose: "true"
          name_top: SramCtrlMainFlopWdataScramble
        }
        {
          name: FlopReadAddrScramble
          desc: Add a flop stage after the address scrambler for reads.
          type: bit
          default: 1
          local: "false"
          expose: "true"
          name_top: SramCtrlMainFlopReadAddrScramble
        }
        {
          name: FlopEccOutput
          desc: Add a flop stage after the ECC output.
          type: bit
          default: "0"
          local: "true"
          expose: "true"
          name_top: SramCtrlMainFlopEccOutput
        }
      ]
      inter_signal_list:
      [
        {
          name: sram_otp_key
          struct: sram_otp_key
          package: otp_ctrl_pkg
          type: req_rsp
          act: req
          width: 1
          inst_name: sram_ctrl_main
          index: -1
        }
        {
          name: cfg
          struct: ram_1p_cfg
          package: prim_ram_1p_pkg
          type: uni
          act: rcv
          width:
          {
            name: NumRamInst
            desc: Number of internal RAM instances. Must be the same as ceil(MemSizeRam / InstSize) .
            param_type: int
            unpacked_dimensions: null
            default: 1
            local: false
            expose: true
            name_top: SramCtrlMainNumRamInst
          }
          default: "'0"
          inst_name: sram_ctrl_main
          external: true
          top_signame: sram_ctrl_main_ram_1p_cfg
          conn_type: false
          index: -1
        }
        {
          name: cfg_rsp
          struct: ram_1p_cfg_rsp
          package: prim_ram_1p_pkg
          type: uni
          act: req
          width:
          {
            name: NumRamInst
            desc: Number of internal RAM instances. Must be the same as ceil(MemSizeRam / InstSize) .
            param_type: int
            unpacked_dimensions: null
            default: 1
            local: false
            expose: true
            name_top: SramCtrlMainNumRamInst
          }
          default: "'0"
          inst_name: sram_ctrl_main
          external: true
          top_signame: sram_ctrl_main_ram_1p_cfg_rsp
          conn_type: false
          index: -1
        }
        {
          name: lc_escalate_en
          struct: lc_tx
          package: lc_ctrl_pkg
          type: uni
          act: rcv
          width: 1
          default: lc_ctrl_pkg::Off
          inst_name: sram_ctrl_main
          top_signame: mio_soc_proxy_lc_escalate_en
          index: -1
        }
        {
          name: lc_hw_debug_en
          struct: lc_tx
          package: lc_ctrl_pkg
          type: uni
          act: rcv
          width: 1
          default: lc_ctrl_pkg::Off
          inst_name: sram_ctrl_main
          top_signame: mio_soc_proxy_lc_hw_debug_en
          index: -1
        }
        {
          name: otp_en_sram_ifetch
          struct: mubi8
          package: prim_mubi_pkg
          type: uni
          act: rcv
          width: 1
          default: prim_mubi_pkg::MuBi8False
          inst_name: sram_ctrl_main
          end_idx: -1
          top_type: broadcast
          top_signame: sram_ctrl_main_otp_en_sram_ifetch
          index: -1
        }
        {
          name: racl_policies
          desc:
            '''
            Incoming RACL policy vector from a racl_ctrl instance.
            The policy selection vector (parameter) selects the policy for each register.
            '''
          struct: racl_policy_vec
          package: top_racl_pkg
          type: uni
          act: rcv
          width: 1
          inst_name: sram_ctrl_main
          default: ""
          top_signame: racl_ctrl_mio_racl_policies
          index: -1
        }
        {
          name: racl_error
          desc: RACL error log information of this module.
          struct: racl_error_log
          package: top_racl_pkg
          type: uni
          act: req
          width: 1
          inst_name: sram_ctrl_main
          default: ""
          top_signame: racl_ctrl_mio_racl_error
          index: 5
        }
        {
          name: sram_rerror
          desc: SRAM read error indicating correctable and uncorrectable ECC errors.
          struct: sram_error_t
          package: sram_ctrl_pkg
          type: uni
          act: req
          width: 1
          inst_name: sram_ctrl_main
          index: -1
        }
        {
          name: regs_tl
          struct: tl
          package: tlul_pkg
          type: req_rsp
          act: rsp
          width: 1
          inst_name: sram_ctrl_main
          default: ""
          end_idx: -1
          top_signame: sram_ctrl_main_regs_tl
          index: -1
        }
        {
          name: ram_tl
          struct: tl
          package: tlul_pkg
          type: req_rsp
          act: rsp
          width: 1
          inst_name: sram_ctrl_main
          default: ""
          end_idx: -1
          top_signame: sram_ctrl_main_ram_tl
          index: -1
        }
      ]
      generate_dif: true
      domain:
      [
        "0"
      ]
    }
    {
      name: sram_ctrl_mbox
      type: sram_ctrl
      clock_srcs:
      {
        clk_i: ext_main
        clk_otp_i: ext_io_div4
      }
      clock_group: infra
      reset_connections:
      {
        rst_ni:
        {
          name: ext_rst_main
          domain: "0"
        }
        rst_otp_ni:
        {
          name: ext_rst_io_div4
          domain: "0"
        }
      }
      param_decl:
      {
        InstrExec: "0"
        InstSize: 4096
        FlopRamOutput: 1
        EccCorrection: 1
        FlopWdataScramble: 1
        FlopReadAddrScramble: 1
        Outstanding: 6
      }
      base_addrs:
      {
        regs:
        {
          hart: 0x211d0000
        }
        ram:
        {
          hart: 0x11000000
        }
      }
      memory:
      {
        ram:
        {
          label: ram_mbox
          swaccess: rw
          data_intg_passthru: "true"
          exec: False
          byte_write: True
          size: 0x1000
        }
      }
      outgoing_alert: mio
      racl_mappings:
      {
        regs:
        {
          racl_group: mio
          register_mapping:
          {
            ALERT_TEST: 6
            STATUS: 0
            EXEC_REGWEN: 0
            EXEC: 0
            CTRL_REGWEN: 0
            CTRL: 0
            SCR_KEY_ROTATED: 0
            READBACK_REGWEN: 0
            READBACK: 0
          }
          window_mapping: {}
          range_mapping: []
        }
      }
      clock_connections:
      {
        clk_i: clk_ext_main_i
        clk_otp_i: clk_ext_io_div4_i
      }
      param_list:
      [
        {
          name: MemSizeRam
          desc: Memory size of the RAM (in bytes).
          type: int
          name_top: MemSizeSramCtrlMboxRam
          default: 4096
        }
        {
          name: InstSize
          desc: Memory size of a single RAM tile (in bytes).
          type: int
          default: 4096
          local: "false"
          expose: "true"
          name_top: SramCtrlMboxInstSize
        }
        {
          name: NumRamInst
          desc: Number of internal RAM instances. Must be the same as ceil(MemSizeRam / InstSize) .
          type: int
          default: 1
          local: "false"
          expose: "true"
          name_top: SramCtrlMboxNumRamInst
        }
        {
          name: InstrExec
          desc: Support execution from SRAM
          type: bit
          default: "0"
          local: "false"
          expose: "true"
          name_top: SramCtrlMboxInstrExec
        }
        {
          name: NumPrinceRoundsHalf
          desc: Number of PRINCE half rounds for the SRAM scrambling feature
          type: int
          default: "3"
          local: "false"
          expose: "true"
          name_top: SramCtrlMboxNumPrinceRoundsHalf
        }
        {
          name: Outstanding
          desc: Number of outstanding TLUL transactions
          type: int
          default: 6
          local: "true"
          expose: "true"
          name_top: SramCtrlMboxOutstanding
        }
        {
          name: EccCorrection
          desc: Enable single-bit error correction and error logging
          type: bit
          default: 1
          local: "false"
          expose: "true"
          name_top: SramCtrlMboxEccCorrection
        }
        {
          name: FlopRamOutput
          desc: Add a flop stage after the RAM macro output.
          type: bit
          default: 1
          local: "false"
          expose: "true"
          name_top: SramCtrlMboxFlopRamOutput
        }
        {
          name: FlopWdataScramble
          desc: Add a flop stage after the write data scrambler.
          type: bit
          default: 1
          local: "false"
          expose: "true"
          name_top: SramCtrlMboxFlopWdataScramble
        }
        {
          name: FlopReadAddrScramble
          desc: Add a flop stage after the address scrambler for reads.
          type: bit
          default: 1
          local: "false"
          expose: "true"
          name_top: SramCtrlMboxFlopReadAddrScramble
        }
        {
          name: FlopEccOutput
          desc: Add a flop stage after the ECC output.
          type: bit
          default: "0"
          local: "true"
          expose: "true"
          name_top: SramCtrlMboxFlopEccOutput
        }
      ]
      inter_signal_list:
      [
        {
          name: sram_otp_key
          struct: sram_otp_key
          package: otp_ctrl_pkg
          type: req_rsp
          act: req
          width: 1
          inst_name: sram_ctrl_mbox
          index: -1
        }
        {
          name: cfg
          struct: ram_1p_cfg
          package: prim_ram_1p_pkg
          type: uni
          act: rcv
          width:
          {
            name: NumRamInst
            desc: Number of internal RAM instances. Must be the same as ceil(MemSizeRam / InstSize) .
            param_type: int
            unpacked_dimensions: null
            default: 1
            local: false
            expose: true
            name_top: SramCtrlMboxNumRamInst
          }
          default: "'0"
          inst_name: sram_ctrl_mbox
          external: true
          top_signame: sram_ctrl_mbox_ram_1p_cfg
          conn_type: false
          index: -1
        }
        {
          name: cfg_rsp
          struct: ram_1p_cfg_rsp
          package: prim_ram_1p_pkg
          type: uni
          act: req
          width:
          {
            name: NumRamInst
            desc: Number of internal RAM instances. Must be the same as ceil(MemSizeRam / InstSize) .
            param_type: int
            unpacked_dimensions: null
            default: 1
            local: false
            expose: true
            name_top: SramCtrlMboxNumRamInst
          }
          default: "'0"
          inst_name: sram_ctrl_mbox
          external: true
          top_signame: sram_ctrl_mbox_ram_1p_cfg_rsp
          conn_type: false
          index: -1
        }
        {
          name: lc_escalate_en
          struct: lc_tx
          package: lc_ctrl_pkg
          type: uni
          act: rcv
          width: 1
          default: lc_ctrl_pkg::Off
          inst_name: sram_ctrl_mbox
          top_signame: mio_soc_proxy_lc_escalate_en
          index: -1
        }
        {
          name: lc_hw_debug_en
          struct: lc_tx
          package: lc_ctrl_pkg
          type: uni
          act: rcv
          width: 1
          default: lc_ctrl_pkg::Off
          inst_name: sram_ctrl_mbox
          top_signame: mio_soc_proxy_lc_hw_debug_en
          index: -1
        }
        {
          name: otp_en_sram_ifetch
          struct: mubi8
          package: prim_mubi_pkg
          type: uni
          act: rcv
          width: 1
          default: prim_mubi_pkg::MuBi8False
          inst_name: sram_ctrl_mbox
          index: -1
        }
        {
          name: racl_policies
          desc:
            '''
            Incoming RACL policy vector from a racl_ctrl instance.
            The policy selection vector (parameter) selects the policy for each register.
            '''
          struct: racl_policy_vec
          package: top_racl_pkg
          type: uni
          act: rcv
          width: 1
          inst_name: sram_ctrl_mbox
          default: ""
          top_signame: racl_ctrl_mio_racl_policies
          index: -1
        }
        {
          name: racl_error
          desc: RACL error log information of this module.
          struct: racl_error_log
          package: top_racl_pkg
          type: uni
          act: req
          width: 1
          inst_name: sram_ctrl_mbox
          default: ""
          top_signame: racl_ctrl_mio_racl_error
          index: 6
        }
        {
          name: sram_rerror
          desc: SRAM read error indicating correctable and uncorrectable ECC errors.
          struct: sram_error_t
          package: sram_ctrl_pkg
          type: uni
          act: req
          width: 1
          inst_name: sram_ctrl_mbox
          index: -1
        }
        {
          name: regs_tl
          struct: tl
          package: tlul_pkg
          type: req_rsp
          act: rsp
          width: 1
          inst_name: sram_ctrl_mbox
          default: ""
          end_idx: -1
          top_signame: sram_ctrl_mbox_regs_tl
          index: -1
        }
        {
          name: ram_tl
          struct: tl
          package: tlul_pkg
          type: req_rsp
          act: rsp
          width: 1
          inst_name: sram_ctrl_mbox
          default: ""
          end_idx: -1
          top_signame: sram_ctrl_mbox_ram_tl
          index: -1
        }
      ]
      generate_dif: true
      domain:
      [
        "0"
      ]
    }
    {
      name: dma
      type: dma
      clock_srcs:
      {
        clk_i: ext_main
      }
      clock_group: infra
      reset_connections:
      {
        rst_ni:
        {
          name: ext_rst_main
          domain: "0"
        }
      }
      outgoing_alert: mio
      clock_connections:
      {
        clk_i: clk_ext_main_i
      }
      param_decl: {}
      memory: {}
      param_list:
      [
        {
          name: EnableDataIntgGen
          desc: Compute integrity bits for A channel data on all TL-UL host ports
          type: bit
          default: 1'b1
          local: "false"
          expose: "true"
          name_top: DmaEnableDataIntgGen
        }
        {
          name: EnableRspDataIntgCheck
          desc: Enable integrity checks on the response TL-UL D channel
          type: bit
          default: 1'b1
          local: "false"
          expose: "true"
          name_top: DmaEnableRspDataIntgCheck
        }
        {
          name: TlUserRsvd
          desc: Value of `rsvd` field in A channel of all TL-UL host ports
          type: logic [tlul_pkg::RsvdWidth-1:0]
          default: "'0"
          local: "false"
          expose: "true"
          name_top: DmaTlUserRsvd
        }
        {
          name: SysRaclRole
          desc: RACL propagated on the Sys interface via `racl_vec`
          type: top_racl_pkg::racl_role_t
          default: "'0"
          local: "false"
          expose: "true"
          name_top: DmaSysRaclRole
        }
        {
          name: OtAgentId
          desc: OT Agent ID
          type: int unsigned
          default: "0"
          local: "false"
          expose: "true"
          name_top: DmaOtAgentId
        }
      ]
      inter_signal_list:
      [
        {
          name: lsio_trigger
          struct: lsio_trigger
          package: dma_pkg
          type: uni
          act: rcv
          width: 1
          inst_name: dma
          default: ""
          end_idx: -1
          top_type: broadcast
          top_signame: dma_lsio_trigger
          index: -1
        }
        {
          name: sys
          desc: SoC System Bus (requests and responses), synchronous
          struct: sys
          package: dma_pkg
          type: req_rsp
          act: req
          width: 1
          inst_name: dma
          default: ""
          external: true
          top_signame: dma_sys
          conn_type: false
          index: -1
        }
        {
          name: ctn_tl_h2d
          desc: TL-UL host port for egress into CTN (request part), synchronous
          struct: tl_h2d
          package: tlul_pkg
          type: uni
          act: req
          width: 1
          inst_name: dma
          default: ""
          top_signame: mio_soc_proxy_dma_tl_h2d
          index: -1
        }
        {
          name: ctn_tl_d2h
          desc: TL-UL host port for egress into CTN (response part), synchronous
          struct: tl_d2h
          package: tlul_pkg
          type: uni
          act: rcv
          width: 1
          inst_name: dma
          default: ""
          top_signame: mio_soc_proxy_dma_tl_d2h
          index: -1
        }
        {
          name: racl_policies
          desc:
            '''
            Incoming RACL policy vector from a racl_ctrl instance.
            The policy selection vector (parameter) selects the policy for each register.
            '''
          struct: racl_policy_vec
          package: top_racl_pkg
          type: uni
          act: rcv
          width: 1
          inst_name: dma
          default: ""
          top_signame: racl_ctrl_mio_racl_policies
          index: -1
        }
        {
          name: racl_error
          desc: RACL error log information of this module.
          struct: racl_error_log
          package: top_racl_pkg
          type: uni
          act: req
          width: 1
          inst_name: dma
          default: ""
          top_signame: racl_ctrl_mio_racl_error
          index: 7
        }
        {
          name: host_tl_h
          struct: tl
          package: tlul_pkg
          type: req_rsp
          act: req
          width: 1
          inst_name: dma
          default: ""
          top_signame: mio_main_tl_dma__host
          index: -1
        }
        {
          name: tl_d
          struct: tl
          package: tlul_pkg
          type: req_rsp
          act: rsp
          width: 1
          inst_name: dma
          default: ""
          end_idx: -1
          top_signame: dma_tl_d
          index: -1
        }
      ]
      base_addrs:
      {
        null:
        {
          hart: 0x22010000
        }
      }
      generate_dif: true
      racl_mappings:
      {
        null:
        {
          racl_group: mio
          register_mapping:
          {
            INTR_STATE: 0
            INTR_ENABLE: 0
            INTR_TEST: 0
            ALERT_TEST: 6
            SRC_ADDR_LO: 0
            SRC_ADDR_HI: 0
            DST_ADDR_LO: 0
            DST_ADDR_HI: 0
            ADDR_SPACE_ID: 0
            ENABLED_MEMORY_RANGE_BASE: 0
            ENABLED_MEMORY_RANGE_LIMIT: 0
            RANGE_VALID: 0
            RANGE_REGWEN: 0
            CFG_REGWEN: 0
            TOTAL_DATA_SIZE: 0
            CHUNK_DATA_SIZE: 0
            TRANSFER_WIDTH: 0
            CONTROL: 0
            SRC_CONFIG: 0
            DST_CONFIG: 0
            STATUS: 0
            ERROR_CODE: 0
            SHA2_DIGEST_0: 0
            SHA2_DIGEST_1: 0
            SHA2_DIGEST_2: 0
            SHA2_DIGEST_3: 0
            SHA2_DIGEST_4: 0
            SHA2_DIGEST_5: 0
            SHA2_DIGEST_6: 0
            SHA2_DIGEST_7: 0
            SHA2_DIGEST_8: 0
            SHA2_DIGEST_9: 0
            SHA2_DIGEST_10: 0
            SHA2_DIGEST_11: 0
            SHA2_DIGEST_12: 0
            SHA2_DIGEST_13: 0
            SHA2_DIGEST_14: 0
            SHA2_DIGEST_15: 0
            HANDSHAKE_INTR_ENABLE: 0
            CLEAR_INTR_SRC: 0
            CLEAR_INTR_BUS: 0
            INTR_SRC_ADDR_0: 0
            INTR_SRC_ADDR_1: 0
            INTR_SRC_ADDR_2: 0
            INTR_SRC_ADDR_3: 0
            INTR_SRC_ADDR_4: 0
            INTR_SRC_ADDR_5: 0
            INTR_SRC_ADDR_6: 0
            INTR_SRC_ADDR_7: 0
            INTR_SRC_ADDR_8: 0
            INTR_SRC_ADDR_9: 0
            INTR_SRC_ADDR_10: 0
            INTR_SRC_WR_VAL_0: 0
            INTR_SRC_WR_VAL_1: 0
            INTR_SRC_WR_VAL_2: 0
            INTR_SRC_WR_VAL_3: 0
            INTR_SRC_WR_VAL_4: 0
            INTR_SRC_WR_VAL_5: 0
            INTR_SRC_WR_VAL_6: 0
            INTR_SRC_WR_VAL_7: 0
            INTR_SRC_WR_VAL_8: 0
            INTR_SRC_WR_VAL_9: 0
            INTR_SRC_WR_VAL_10: 0
          }
          window_mapping: {}
          range_mapping: []
        }
      }
      domain:
      [
        "0"
      ]
    }
    {
      name: mbx0
      type: mbx
      clock_srcs:
      {
        clk_i: ext_main
      }
      clock_group: infra
      reset_connections:
      {
        rst_ni:
        {
          name: ext_rst_main
          domain: "0"
        }
      }
      base_addrs:
      {
        core:
        {
          hart: 0x22000000
        }
        soc:
        {
          soc_mbx: 0x01485000
        }
      }
      outgoing_alert: mio
      racl_mappings:
      {
        core:
        {
          racl_group: mio
          register_mapping:
          {
            INTR_STATE: 0
            INTR_ENABLE: 0
            INTR_TEST: 0
            ALERT_TEST: 6
            CONTROL: 0
            STATUS: 0
            ADDRESS_RANGE_REGWEN: 0
            ADDRESS_RANGE_VALID: 0
            INBOUND_BASE_ADDRESS: 0
            INBOUND_LIMIT_ADDRESS: 0
            INBOUND_WRITE_PTR: 0
            OUTBOUND_BASE_ADDRESS: 0
            OUTBOUND_LIMIT_ADDRESS: 0
            OUTBOUND_READ_PTR: 0
            OUTBOUND_OBJECT_SIZE: 0
            DOE_INTR_MSG_ADDR: 0
            DOE_INTR_MSG_DATA: 0
          }
          window_mapping: {}
          range_mapping: []
        }
        soc:
        {
          racl_group: mio
          register_mapping:
          {
            SOC_CONTROL: 8
            SOC_STATUS: 8
            SOC_DOE_INTR_MSG_ADDR: 8
            SOC_DOE_INTR_MSG_DATA: 8
          }
          window_mapping:
          {
            WDATA: 8
            RDATA: 8
          }
          range_mapping: []
        }
      }
      clock_connections:
      {
        clk_i: clk_ext_main_i
      }
      param_decl: {}
      memory: {}
      param_list: []
      inter_signal_list:
      [
        {
          name: doe_intr_support
          struct: logic
          type: uni
          act: req
          width: 1
          default: 1'b0
          inst_name: mbx0
          index: -1
        }
        {
          name: doe_intr_en
          struct: logic
          type: uni
          act: req
          width: 1
          default: 1'b0
          inst_name: mbx0
          index: -1
        }
        {
          name: doe_intr
          struct: logic
          type: uni
          act: req
          width: 1
          default: 1'b0
          inst_name: mbx0
          index: -1
        }
        {
          name: doe_async_msg_support
          struct: logic
          type: uni
          act: req
          width: 1
          default: 1'b0
          inst_name: mbx0
          index: -1
        }
        {
          name: racl_policies
          desc:
            '''
            Incoming RACL policy vector from a racl_ctrl instance.
            The policy selection vector (parameter) selects the policy for each register.
            '''
          struct: racl_policy_vec
          package: top_racl_pkg
          type: uni
          act: rcv
          width: 1
          inst_name: mbx0
          default: ""
          top_signame: racl_ctrl_mio_racl_policies
          index: -1
        }
        {
          name: racl_error
          desc: RACL error log information of this module.
          struct: racl_error_log
          package: top_racl_pkg
          type: uni
          act: req
          width: 1
          inst_name: mbx0
          default: ""
          top_signame: racl_ctrl_mio_racl_error
          index: 8
        }
        {
          name: sram_tl_h
          struct: tl
          package: tlul_pkg
          type: req_rsp
          act: req
          width: 1
          inst_name: mbx0
          default: ""
          top_signame: mio_main_tl_mbx0__sram
          index: -1
        }
        {
          name: core_tl_d
          struct: tl
          package: tlul_pkg
          type: req_rsp
          act: rsp
          width: 1
          inst_name: mbx0
          default: ""
          end_idx: -1
          top_signame: mbx0_core_tl_d
          index: -1
        }
        {
          name: soc_tl_d
          struct: tl
          package: tlul_pkg
          type: req_rsp
          act: rsp
          width: 1
          inst_name: mbx0
          default: ""
          end_idx: -1
          top_signame: mbx0_soc_tl_d
          index: -1
        }
      ]
      generate_dif: true
      domain:
      [
        "0"
      ]
    }
    {
      name: mbx1
      type: mbx
      clock_srcs:
      {
        clk_i: ext_main
      }
      clock_group: infra
      reset_connections:
      {
        rst_ni:
        {
          name: ext_rst_main
          domain: "0"
        }
      }
      base_addrs:
      {
        core:
        {
          hart: 0x22000100
        }
        soc:
        {
          soc_mbx: 0x01485100
        }
      }
      outgoing_alert: mio
      racl_mappings:
      {
        core:
        {
          racl_group: mio
          register_mapping:
          {
            INTR_STATE: 0
            INTR_ENABLE: 0
            INTR_TEST: 0
            ALERT_TEST: 6
            CONTROL: 0
            STATUS: 0
            ADDRESS_RANGE_REGWEN: 0
            ADDRESS_RANGE_VALID: 0
            INBOUND_BASE_ADDRESS: 0
            INBOUND_LIMIT_ADDRESS: 0
            INBOUND_WRITE_PTR: 0
            OUTBOUND_BASE_ADDRESS: 0
            OUTBOUND_LIMIT_ADDRESS: 0
            OUTBOUND_READ_PTR: 0
            OUTBOUND_OBJECT_SIZE: 0
            DOE_INTR_MSG_ADDR: 0
            DOE_INTR_MSG_DATA: 0
          }
          window_mapping: {}
          range_mapping: []
        }
        soc:
        {
          racl_group: mio
          register_mapping:
          {
            SOC_CONTROL: 8
            SOC_STATUS: 8
            SOC_DOE_INTR_MSG_ADDR: 8
            SOC_DOE_INTR_MSG_DATA: 8
          }
          window_mapping:
          {
            WDATA: 8
            RDATA: 8
          }
          range_mapping: []
        }
      }
      clock_connections:
      {
        clk_i: clk_ext_main_i
      }
      param_decl: {}
      memory: {}
      param_list: []
      inter_signal_list:
      [
        {
          name: doe_intr_support
          struct: logic
          type: uni
          act: req
          width: 1
          default: 1'b0
          inst_name: mbx1
          index: -1
        }
        {
          name: doe_intr_en
          struct: logic
          type: uni
          act: req
          width: 1
          default: 1'b0
          inst_name: mbx1
          index: -1
        }
        {
          name: doe_intr
          struct: logic
          type: uni
          act: req
          width: 1
          default: 1'b0
          inst_name: mbx1
          index: -1
        }
        {
          name: doe_async_msg_support
          struct: logic
          type: uni
          act: req
          width: 1
          default: 1'b0
          inst_name: mbx1
          index: -1
        }
        {
          name: racl_policies
          desc:
            '''
            Incoming RACL policy vector from a racl_ctrl instance.
            The policy selection vector (parameter) selects the policy for each register.
            '''
          struct: racl_policy_vec
          package: top_racl_pkg
          type: uni
          act: rcv
          width: 1
          inst_name: mbx1
          default: ""
          top_signame: racl_ctrl_mio_racl_policies
          index: -1
        }
        {
          name: racl_error
          desc: RACL error log information of this module.
          struct: racl_error_log
          package: top_racl_pkg
          type: uni
          act: req
          width: 1
          inst_name: mbx1
          default: ""
          top_signame: racl_ctrl_mio_racl_error
          index: 9
        }
        {
          name: sram_tl_h
          struct: tl
          package: tlul_pkg
          type: req_rsp
          act: req
          width: 1
          inst_name: mbx1
          default: ""
          top_signame: mio_main_tl_mbx1__sram
          index: -1
        }
        {
          name: core_tl_d
          struct: tl
          package: tlul_pkg
          type: req_rsp
          act: rsp
          width: 1
          inst_name: mbx1
          default: ""
          end_idx: -1
          top_signame: mbx1_core_tl_d
          index: -1
        }
        {
          name: soc_tl_d
          struct: tl
          package: tlul_pkg
          type: req_rsp
          act: rsp
          width: 1
          inst_name: mbx1
          default: ""
          end_idx: -1
          top_signame: mbx1_soc_tl_d
          index: -1
        }
      ]
      generate_dif: true
      domain:
      [
        "0"
      ]
    }
    {
      name: mbx2
      type: mbx
      clock_srcs:
      {
        clk_i: ext_main
      }
      clock_group: infra
      reset_connections:
      {
        rst_ni:
        {
          name: ext_rst_main
          domain: "0"
        }
      }
      base_addrs:
      {
        core:
        {
          hart: 0x22000200
        }
        soc:
        {
          soc_mbx: 0x01485200
        }
      }
      outgoing_alert: mio
      racl_mappings:
      {
        core:
        {
          racl_group: mio
          register_mapping:
          {
            INTR_STATE: 0
            INTR_ENABLE: 0
            INTR_TEST: 0
            ALERT_TEST: 6
            CONTROL: 0
            STATUS: 0
            ADDRESS_RANGE_REGWEN: 0
            ADDRESS_RANGE_VALID: 0
            INBOUND_BASE_ADDRESS: 0
            INBOUND_LIMIT_ADDRESS: 0
            INBOUND_WRITE_PTR: 0
            OUTBOUND_BASE_ADDRESS: 0
            OUTBOUND_LIMIT_ADDRESS: 0
            OUTBOUND_READ_PTR: 0
            OUTBOUND_OBJECT_SIZE: 0
            DOE_INTR_MSG_ADDR: 0
            DOE_INTR_MSG_DATA: 0
          }
          window_mapping: {}
          range_mapping: []
        }
        soc:
        {
          racl_group: mio
          register_mapping:
          {
            SOC_CONTROL: 8
            SOC_STATUS: 8
            SOC_DOE_INTR_MSG_ADDR: 8
            SOC_DOE_INTR_MSG_DATA: 8
          }
          window_mapping:
          {
            WDATA: 8
            RDATA: 8
          }
          range_mapping: []
        }
      }
      clock_connections:
      {
        clk_i: clk_ext_main_i
      }
      param_decl: {}
      memory: {}
      param_list: []
      inter_signal_list:
      [
        {
          name: doe_intr_support
          struct: logic
          type: uni
          act: req
          width: 1
          default: 1'b0
          inst_name: mbx2
          index: -1
        }
        {
          name: doe_intr_en
          struct: logic
          type: uni
          act: req
          width: 1
          default: 1'b0
          inst_name: mbx2
          index: -1
        }
        {
          name: doe_intr
          struct: logic
          type: uni
          act: req
          width: 1
          default: 1'b0
          inst_name: mbx2
          index: -1
        }
        {
          name: doe_async_msg_support
          struct: logic
          type: uni
          act: req
          width: 1
          default: 1'b0
          inst_name: mbx2
          index: -1
        }
        {
          name: racl_policies
          desc:
            '''
            Incoming RACL policy vector from a racl_ctrl instance.
            The policy selection vector (parameter) selects the policy for each register.
            '''
          struct: racl_policy_vec
          package: top_racl_pkg
          type: uni
          act: rcv
          width: 1
          inst_name: mbx2
          default: ""
          top_signame: racl_ctrl_mio_racl_policies
          index: -1
        }
        {
          name: racl_error
          desc: RACL error log information of this module.
          struct: racl_error_log
          package: top_racl_pkg
          type: uni
          act: req
          width: 1
          inst_name: mbx2
          default: ""
          top_signame: racl_ctrl_mio_racl_error
          index: 10
        }
        {
          name: sram_tl_h
          struct: tl
          package: tlul_pkg
          type: req_rsp
          act: req
          width: 1
          inst_name: mbx2
          default: ""
          top_signame: mio_main_tl_mbx2__sram
          index: -1
        }
        {
          name: core_tl_d
          struct: tl
          package: tlul_pkg
          type: req_rsp
          act: rsp
          width: 1
          inst_name: mbx2
          default: ""
          end_idx: -1
          top_signame: mbx2_core_tl_d
          index: -1
        }
        {
          name: soc_tl_d
          struct: tl
          package: tlul_pkg
          type: req_rsp
          act: rsp
          width: 1
          inst_name: mbx2
          default: ""
          end_idx: -1
          top_signame: mbx2_soc_tl_d
          index: -1
        }
      ]
      generate_dif: true
      domain:
      [
        "0"
      ]
    }
    {
      name: mbx3
      type: mbx
      clock_srcs:
      {
        clk_i: ext_main
      }
      clock_group: infra
      reset_connections:
      {
        rst_ni:
        {
          name: ext_rst_main
          domain: "0"
        }
      }
      base_addrs:
      {
        core:
        {
          hart: 0x22000300
        }
        soc:
        {
          soc_mbx: 0x01485300
        }
      }
      outgoing_alert: mio
      racl_mappings:
      {
        core:
        {
          racl_group: mio
          register_mapping:
          {
            INTR_STATE: 0
            INTR_ENABLE: 0
            INTR_TEST: 0
            ALERT_TEST: 6
            CONTROL: 0
            STATUS: 0
            ADDRESS_RANGE_REGWEN: 0
            ADDRESS_RANGE_VALID: 0
            INBOUND_BASE_ADDRESS: 0
            INBOUND_LIMIT_ADDRESS: 0
            INBOUND_WRITE_PTR: 0
            OUTBOUND_BASE_ADDRESS: 0
            OUTBOUND_LIMIT_ADDRESS: 0
            OUTBOUND_READ_PTR: 0
            OUTBOUND_OBJECT_SIZE: 0
            DOE_INTR_MSG_ADDR: 0
            DOE_INTR_MSG_DATA: 0
          }
          window_mapping: {}
          range_mapping: []
        }
        soc:
        {
          racl_group: mio
          register_mapping:
          {
            SOC_CONTROL: 6
            SOC_STATUS: 6
            SOC_DOE_INTR_MSG_ADDR: 6
            SOC_DOE_INTR_MSG_DATA: 6
          }
          window_mapping:
          {
            WDATA: 6
            RDATA: 6
          }
          range_mapping: []
        }
      }
      clock_connections:
      {
        clk_i: clk_ext_main_i
      }
      param_decl: {}
      memory: {}
      param_list: []
      inter_signal_list:
      [
        {
          name: doe_intr_support
          struct: logic
          type: uni
          act: req
          width: 1
          default: 1'b0
          inst_name: mbx3
          index: -1
        }
        {
          name: doe_intr_en
          struct: logic
          type: uni
          act: req
          width: 1
          default: 1'b0
          inst_name: mbx3
          index: -1
        }
        {
          name: doe_intr
          struct: logic
          type: uni
          act: req
          width: 1
          default: 1'b0
          inst_name: mbx3
          index: -1
        }
        {
          name: doe_async_msg_support
          struct: logic
          type: uni
          act: req
          width: 1
          default: 1'b0
          inst_name: mbx3
          index: -1
        }
        {
          name: racl_policies
          desc:
            '''
            Incoming RACL policy vector from a racl_ctrl instance.
            The policy selection vector (parameter) selects the policy for each register.
            '''
          struct: racl_policy_vec
          package: top_racl_pkg
          type: uni
          act: rcv
          width: 1
          inst_name: mbx3
          default: ""
          top_signame: racl_ctrl_mio_racl_policies
          index: -1
        }
        {
          name: racl_error
          desc: RACL error log information of this module.
          struct: racl_error_log
          package: top_racl_pkg
          type: uni
          act: req
          width: 1
          inst_name: mbx3
          default: ""
          top_signame: racl_ctrl_mio_racl_error
          index: 11
        }
        {
          name: sram_tl_h
          struct: tl
          package: tlul_pkg
          type: req_rsp
          act: req
          width: 1
          inst_name: mbx3
          default: ""
          top_signame: mio_main_tl_mbx3__sram
          index: -1
        }
        {
          name: core_tl_d
          struct: tl
          package: tlul_pkg
          type: req_rsp
          act: rsp
          width: 1
          inst_name: mbx3
          default: ""
          end_idx: -1
          top_signame: mbx3_core_tl_d
          index: -1
        }
        {
          name: soc_tl_d
          struct: tl
          package: tlul_pkg
          type: req_rsp
          act: rsp
          width: 1
          inst_name: mbx3
          default: ""
          end_idx: -1
          top_signame: mbx3_soc_tl_d
          index: -1
        }
      ]
      generate_dif: true
      domain:
      [
        "0"
      ]
    }
    {
      name: mbx4
      type: mbx
      clock_srcs:
      {
        clk_i: ext_main
      }
      clock_group: infra
      reset_connections:
      {
        rst_ni:
        {
          name: ext_rst_main
          domain: "0"
        }
      }
      base_addrs:
      {
        core:
        {
          hart: 0x22000400
        }
        soc:
        {
          soc_mbx: 0x01485400
        }
      }
      outgoing_alert: mio
      racl_mappings:
      {
        core:
        {
          racl_group: mio
          register_mapping:
          {
            INTR_STATE: 0
            INTR_ENABLE: 0
            INTR_TEST: 0
            ALERT_TEST: 6
            CONTROL: 0
            STATUS: 0
            ADDRESS_RANGE_REGWEN: 0
            ADDRESS_RANGE_VALID: 0
            INBOUND_BASE_ADDRESS: 0
            INBOUND_LIMIT_ADDRESS: 0
            INBOUND_WRITE_PTR: 0
            OUTBOUND_BASE_ADDRESS: 0
            OUTBOUND_LIMIT_ADDRESS: 0
            OUTBOUND_READ_PTR: 0
            OUTBOUND_OBJECT_SIZE: 0
            DOE_INTR_MSG_ADDR: 0
            DOE_INTR_MSG_DATA: 0
          }
          window_mapping: {}
          range_mapping: []
        }
        soc:
        {
          racl_group: mio
          register_mapping:
          {
            SOC_CONTROL: 7
            SOC_STATUS: 7
            SOC_DOE_INTR_MSG_ADDR: 7
            SOC_DOE_INTR_MSG_DATA: 7
          }
          window_mapping:
          {
            WDATA: 7
            RDATA: 7
          }
          range_mapping: []
        }
      }
      clock_connections:
      {
        clk_i: clk_ext_main_i
      }
      param_decl: {}
      memory: {}
      param_list: []
      inter_signal_list:
      [
        {
          name: doe_intr_support
          struct: logic
          type: uni
          act: req
          width: 1
          default: 1'b0
          inst_name: mbx4
          index: -1
        }
        {
          name: doe_intr_en
          struct: logic
          type: uni
          act: req
          width: 1
          default: 1'b0
          inst_name: mbx4
          index: -1
        }
        {
          name: doe_intr
          struct: logic
          type: uni
          act: req
          width: 1
          default: 1'b0
          inst_name: mbx4
          index: -1
        }
        {
          name: doe_async_msg_support
          struct: logic
          type: uni
          act: req
          width: 1
          default: 1'b0
          inst_name: mbx4
          index: -1
        }
        {
          name: racl_policies
          desc:
            '''
            Incoming RACL policy vector from a racl_ctrl instance.
            The policy selection vector (parameter) selects the policy for each register.
            '''
          struct: racl_policy_vec
          package: top_racl_pkg
          type: uni
          act: rcv
          width: 1
          inst_name: mbx4
          default: ""
          top_signame: racl_ctrl_mio_racl_policies
          index: -1
        }
        {
          name: racl_error
          desc: RACL error log information of this module.
          struct: racl_error_log
          package: top_racl_pkg
          type: uni
          act: req
          width: 1
          inst_name: mbx4
          default: ""
          top_signame: racl_ctrl_mio_racl_error
          index: 12
        }
        {
          name: sram_tl_h
          struct: tl
          package: tlul_pkg
          type: req_rsp
          act: req
          width: 1
          inst_name: mbx4
          default: ""
          top_signame: mio_main_tl_mbx4__sram
          index: -1
        }
        {
          name: core_tl_d
          struct: tl
          package: tlul_pkg
          type: req_rsp
          act: rsp
          width: 1
          inst_name: mbx4
          default: ""
          end_idx: -1
          top_signame: mbx4_core_tl_d
          index: -1
        }
        {
          name: soc_tl_d
          struct: tl
          package: tlul_pkg
          type: req_rsp
          act: rsp
          width: 1
          inst_name: mbx4
          default: ""
          end_idx: -1
          top_signame: mbx4_soc_tl_d
          index: -1
        }
      ]
      generate_dif: true
      domain:
      [
        "0"
      ]
    }
    {
      name: mbx5
      type: mbx
      clock_srcs:
      {
        clk_i: ext_main
      }
      clock_group: infra
      reset_connections:
      {
        rst_ni:
        {
          name: ext_rst_main
          domain: "0"
        }
      }
      base_addrs:
      {
        core:
        {
          hart: 0x22000500
        }
        soc:
        {
          soc_mbx: 0x01485500
        }
      }
      outgoing_alert: mio
      racl_mappings:
      {
        core:
        {
          racl_group: mio
          register_mapping:
          {
            INTR_STATE: 0
            INTR_ENABLE: 0
            INTR_TEST: 0
            ALERT_TEST: 6
            CONTROL: 0
            STATUS: 0
            ADDRESS_RANGE_REGWEN: 0
            ADDRESS_RANGE_VALID: 0
            INBOUND_BASE_ADDRESS: 0
            INBOUND_LIMIT_ADDRESS: 0
            INBOUND_WRITE_PTR: 0
            OUTBOUND_BASE_ADDRESS: 0
            OUTBOUND_LIMIT_ADDRESS: 0
            OUTBOUND_READ_PTR: 0
            OUTBOUND_OBJECT_SIZE: 0
            DOE_INTR_MSG_ADDR: 0
            DOE_INTR_MSG_DATA: 0
          }
          window_mapping: {}
          range_mapping: []
        }
        soc:
        {
          racl_group: mio
          register_mapping:
          {
            SOC_CONTROL: 9
            SOC_STATUS: 9
            SOC_DOE_INTR_MSG_ADDR: 9
            SOC_DOE_INTR_MSG_DATA: 9
          }
          window_mapping:
          {
            WDATA: 9
            RDATA: 9
          }
          range_mapping: []
        }
      }
      clock_connections:
      {
        clk_i: clk_ext_main_i
      }
      param_decl: {}
      memory: {}
      param_list: []
      inter_signal_list:
      [
        {
          name: doe_intr_support
          struct: logic
          type: uni
          act: req
          width: 1
          default: 1'b0
          inst_name: mbx5
          index: -1
        }
        {
          name: doe_intr_en
          struct: logic
          type: uni
          act: req
          width: 1
          default: 1'b0
          inst_name: mbx5
          index: -1
        }
        {
          name: doe_intr
          struct: logic
          type: uni
          act: req
          width: 1
          default: 1'b0
          inst_name: mbx5
          index: -1
        }
        {
          name: doe_async_msg_support
          struct: logic
          type: uni
          act: req
          width: 1
          default: 1'b0
          inst_name: mbx5
          index: -1
        }
        {
          name: racl_policies
          desc:
            '''
            Incoming RACL policy vector from a racl_ctrl instance.
            The policy selection vector (parameter) selects the policy for each register.
            '''
          struct: racl_policy_vec
          package: top_racl_pkg
          type: uni
          act: rcv
          width: 1
          inst_name: mbx5
          default: ""
          top_signame: racl_ctrl_mio_racl_policies
          index: -1
        }
        {
          name: racl_error
          desc: RACL error log information of this module.
          struct: racl_error_log
          package: top_racl_pkg
          type: uni
          act: req
          width: 1
          inst_name: mbx5
          default: ""
          top_signame: racl_ctrl_mio_racl_error
          index: 13
        }
        {
          name: sram_tl_h
          struct: tl
          package: tlul_pkg
          type: req_rsp
          act: req
          width: 1
          inst_name: mbx5
          default: ""
          top_signame: mio_main_tl_mbx5__sram
          index: -1
        }
        {
          name: core_tl_d
          struct: tl
          package: tlul_pkg
          type: req_rsp
          act: rsp
          width: 1
          inst_name: mbx5
          default: ""
          end_idx: -1
          top_signame: mbx5_core_tl_d
          index: -1
        }
        {
          name: soc_tl_d
          struct: tl
          package: tlul_pkg
          type: req_rsp
          act: rsp
          width: 1
          inst_name: mbx5
          default: ""
          end_idx: -1
          top_signame: mbx5_soc_tl_d
          index: -1
        }
      ]
      generate_dif: true
      domain:
      [
        "0"
      ]
    }
    {
      name: mbx_pcie0
      type: mbx
      clock_srcs:
      {
        clk_i: ext_main
      }
      clock_group: infra
      reset_connections:
      {
        rst_ni:
        {
          name: ext_rst_main
          domain: "0"
        }
      }
      base_addrs:
      {
        core:
        {
          hart: 0x22040000
        }
        soc:
        {
          soc_mbx: 0x01480100
        }
      }
      outgoing_alert: mio
      racl_mappings:
      {
        core:
        {
          racl_group: mio
          register_mapping:
          {
            INTR_STATE: 0
            INTR_ENABLE: 0
            INTR_TEST: 0
            ALERT_TEST: 6
            CONTROL: 0
            STATUS: 0
            ADDRESS_RANGE_REGWEN: 0
            ADDRESS_RANGE_VALID: 0
            INBOUND_BASE_ADDRESS: 0
            INBOUND_LIMIT_ADDRESS: 0
            INBOUND_WRITE_PTR: 0
            OUTBOUND_BASE_ADDRESS: 0
            OUTBOUND_LIMIT_ADDRESS: 0
            OUTBOUND_READ_PTR: 0
            OUTBOUND_OBJECT_SIZE: 0
            DOE_INTR_MSG_ADDR: 0
            DOE_INTR_MSG_DATA: 0
          }
          window_mapping: {}
          range_mapping: []
        }
        soc:
        {
          racl_group: mio
          register_mapping:
          {
            SOC_CONTROL: 0
            SOC_STATUS: 0
            SOC_DOE_INTR_MSG_ADDR: 0
            SOC_DOE_INTR_MSG_DATA: 0
          }
          window_mapping:
          {
            WDATA: 0
            RDATA: 0
          }
          range_mapping: []
        }
      }
      clock_connections:
      {
        clk_i: clk_ext_main_i
      }
      param_decl: {}
      memory: {}
      param_list: []
      inter_signal_list:
      [
        {
          name: doe_intr_support
          struct: logic
          type: uni
          act: req
          width: 1
          default: 1'b0
          inst_name: mbx_pcie0
          index: -1
        }
        {
          name: doe_intr_en
          struct: logic
          type: uni
          act: req
          width: 1
          default: 1'b0
          inst_name: mbx_pcie0
          index: -1
        }
        {
          name: doe_intr
          struct: logic
          type: uni
          act: req
          width: 1
          default: 1'b0
          inst_name: mbx_pcie0
          index: -1
        }
        {
          name: doe_async_msg_support
          struct: logic
          type: uni
          act: req
          width: 1
          default: 1'b0
          inst_name: mbx_pcie0
          index: -1
        }
        {
          name: racl_policies
          desc:
            '''
            Incoming RACL policy vector from a racl_ctrl instance.
            The policy selection vector (parameter) selects the policy for each register.
            '''
          struct: racl_policy_vec
          package: top_racl_pkg
          type: uni
          act: rcv
          width: 1
          inst_name: mbx_pcie0
          default: ""
          top_signame: racl_ctrl_mio_racl_policies
          index: -1
        }
        {
          name: racl_error
          desc: RACL error log information of this module.
          struct: racl_error_log
          package: top_racl_pkg
          type: uni
          act: req
          width: 1
          inst_name: mbx_pcie0
          default: ""
          top_signame: racl_ctrl_mio_racl_error
          index: 14
        }
        {
          name: sram_tl_h
          struct: tl
          package: tlul_pkg
          type: req_rsp
          act: req
          width: 1
          inst_name: mbx_pcie0
          default: ""
          top_signame: mio_main_tl_mbx_pcie0__sram
          index: -1
        }
        {
          name: core_tl_d
          struct: tl
          package: tlul_pkg
          type: req_rsp
          act: rsp
          width: 1
          inst_name: mbx_pcie0
          default: ""
          end_idx: -1
          top_signame: mbx_pcie0_core_tl_d
          index: -1
        }
        {
          name: soc_tl_d
          struct: tl
          package: tlul_pkg
          type: req_rsp
          act: rsp
          width: 1
          inst_name: mbx_pcie0
          default: ""
          end_idx: -1
          top_signame: mbx_pcie0_soc_tl_d
          index: -1
        }
      ]
      generate_dif: true
      domain:
      [
        "0"
      ]
    }
    {
      name: racl_ctrl_mio
      type: racl_ctrl_mio
      template_type: racl_ctrl
      clock_srcs:
      {
        clk_i: ext_main
      }
      clock_group: infra
      reset_connections:
      {
        rst_ni:
        {
          name: ext_rst_main
          domain: "0"
        }
      }
      attr: ipgen
      ipgen_params:
      {
        racl_group: mio
        use_rivos_config: true
      }
      outgoing_alert: mio
      outgoing_interrupt: mio
      clock_connections:
      {
        clk_i: clk_ext_main_i
      }
      param_decl: {}
      memory: {}
      param_list:
      [
        {
          name: NumSubscribingIps
          desc: Number of subscribing RACL IPs
          type: int
          default: 17
          local: "true"
          expose: "true"
          name_top: RaclCtrlMioNumSubscribingIps
        }
        {
          name: NumExternalSubscribingIps
          desc: Number of external subscribing RACL IPs
          type: int
          default: 1
          local: "false"
          expose: "true"
          name_top: RaclCtrlMioNumExternalSubscribingIps
        }
      ]
      inter_signal_list:
      [
        {
          name: racl_policies
          desc: Policy vector distributed to the subscribing RACL IPs.
          struct: racl_policy_vec
          package: top_racl_pkg
          type: uni
          act: req
          width: 1
          inst_name: racl_ctrl_mio
          default: ""
          end_idx: -1
          top_type: broadcast
          top_signame: racl_ctrl_mio_racl_policies
          index: -1
          external: true
          conn_type: true
        }
        {
          name: racl_error
          desc:
            '''
            Error log information from all IPs.
            Only one IP can raise an error at a time.
            '''
          struct: racl_error_log
          package: top_racl_pkg
          type: uni
          act: rcv
          width:
          {
            name: NumSubscribingIps
            desc: Number of subscribing RACL IPs
            param_type: int
            unpacked_dimensions: null
            default: 17
            local: true
            expose: true
            name_top: RaclCtrlMioNumSubscribingIps
          }
          inst_name: racl_ctrl_mio
          default: ""
          end_idx: -1
          top_type: one-to-N
          top_signame: racl_ctrl_mio_racl_error
          index: -1
        }
        {
          name: racl_error_external
          desc:
            '''
            Error log information from all external IPs.
            Only one IP can raise an error at a time.
            '''
          struct: racl_error_log
          package: top_racl_pkg
          type: uni
          act: rcv
          width:
          {
            name: NumExternalSubscribingIps
            desc: Number of external subscribing RACL IPs
            param_type: int
            unpacked_dimensions: null
            default: 1
            local: false
            expose: true
            name_top: RaclCtrlMioNumExternalSubscribingIps
          }
          inst_name: racl_ctrl_mio
          default: ""
          external: true
          top_signame: racl_error
          conn_type: false
          index: -1
        }
        {
          name: tl
          struct: tl
          package: tlul_pkg
          type: req_rsp
          act: rsp
          width: 1
          inst_name: racl_ctrl_mio
          default: ""
          end_idx: -1
          top_signame: racl_ctrl_mio_tl
          index: -1
        }
      ]
      base_addrs:
      {
        null:
        {
          soc_mbx: 0x01481f00
        }
      }
      generate_dif: true
      domain:
      [
        "0"
      ]
    }
    {
      name: ac_range_check_mio
      type: ac_range_check_mio
      template_type: ac_range_check
      clock_srcs:
      {
        clk_i: ext_main
      }
      clock_group: secure
      reset_connections:
      {
        rst_ni:
        {
          name: ext_rst_main
          domain: "0"
        }
      }
      param_decl:
      {
        RangeCheckErrorRsp: 0
      }
      ipgen_params:
      {
        num_ranges: 32
      }
      attr: ipgen
      outgoing_alert: mio
      outgoing_interrupt: mio
      clock_connections:
      {
        clk_i: clk_ext_main_i
      }
      memory: {}
      param_list:
      [
        {
          name: RangeCheckErrorRsp
          desc:
            '''
            Error behavior on blocked requests:
            1: A denied request returns a TLUL error (.d_error = 1 on the response)
            0: Writes are dropped and reads return all-zero, without a TLUL error
            '''
          type: bit
          default: 0
          local: "false"
          expose: "true"
          name_top: AcRangeCheckMioRangeCheckErrorRsp
        }
      ]
      inter_signal_list:
      [
        {
          name: range_check_overwrite
          desc: Overwrites all ranges and let all requests pass through.
          struct: mubi8
          package: prim_mubi_pkg
          type: uni
          act: rcv
          width: 1
          inst_name: ac_range_check_mio
          default: ""
          external: true
          top_signame: ac_range_check_overwrite
          conn_type: false
          index: -1
        }
        {
          name: ctn_tl_h2d
          desc: TL-UL input port (request part), synchronous
          struct: tl_h2d
          package: tlul_pkg
          type: uni
          act: rcv
          width: 1
          inst_name: ac_range_check_mio
          default: ""
          top_signame: mio_soc_proxy_muxed_tl_h2d
          index: -1
        }
        {
          name: ctn_tl_d2h
          desc: TL-UL input port (response part), synchronous
          struct: tl_d2h
          package: tlul_pkg
          type: uni
          act: req
          width: 1
          inst_name: ac_range_check_mio
          default: ""
          top_signame: mio_soc_proxy_muxed_tl_d2h
          index: -1
        }
        {
          name: ctn_filtered_tl_h2d
          desc: Filtered TL-UL output port (request part), synchronous
          struct: tl_h2d
          package: tlul_pkg
          type: uni
          act: req
          width: 1
          inst_name: ac_range_check_mio
          default: ""
          end_idx: -1
          top_type: broadcast
          top_signame: ac_range_check_mio_ctn_filtered_tl_h2d
          index: -1
        }
        {
          name: ctn_filtered_tl_d2h
          desc: Filtered TL-UL output port (response part), synchronous
          struct: tl_d2h
          package: tlul_pkg
          type: uni
          act: rcv
          width: 1
          inst_name: ac_range_check_mio
          default: ""
          end_idx: -1
          top_type: broadcast
          top_signame: ac_range_check_mio_ctn_filtered_tl_d2h
          index: -1
        }
        {
          name: racl_policies
          desc:
            '''
            Incoming RACL policy vector from a racl_ctrl instance.
            The policy selection vector (parameter) selects the policy for each register.
            '''
          struct: racl_policy_vec
          package: top_racl_pkg
          type: uni
          act: rcv
          width: 1
          inst_name: ac_range_check_mio
          default: ""
          top_signame: racl_ctrl_mio_racl_policies
          index: -1
        }
        {
          name: racl_error
          desc: RACL error log information of this module.
          struct: racl_error_log
          package: top_racl_pkg
          type: uni
          act: req
          width: 1
          inst_name: ac_range_check_mio
          default: ""
          top_signame: racl_ctrl_mio_racl_error
          index: 15
        }
        {
          name: tl
          struct: tl
          package: tlul_pkg
          type: req_rsp
          act: rsp
          width: 1
          inst_name: ac_range_check_mio
          default: ""
          end_idx: -1
          top_signame: ac_range_check_mio_tl
          index: -1
        }
      ]
      base_addrs:
      {
        null:
        {
          soc_mbx: 0x01484000
        }
      }
      generate_dif: true
      racl_mappings:
      {
        null:
        {
          racl_group: mio
          register_mapping:
          {
            INTR_STATE: 6
            INTR_ENABLE: 6
            INTR_TEST: 6
            ALERT_TEST: 6
            ALERT_STATUS: 6
            LOG_CONFIG: 6
            LOG_STATUS: 6
            LOG_ADDRESS: 6
            RANGE_REGWEN_0: 6
            RANGE_REGWEN_1: 6
            RANGE_REGWEN_2: 6
            RANGE_REGWEN_3: 6
            RANGE_REGWEN_4: 6
            RANGE_REGWEN_5: 6
            RANGE_REGWEN_6: 6
            RANGE_REGWEN_7: 6
            RANGE_REGWEN_8: 6
            RANGE_REGWEN_9: 6
            RANGE_REGWEN_10: 6
            RANGE_REGWEN_11: 6
            RANGE_REGWEN_12: 6
            RANGE_REGWEN_13: 6
            RANGE_REGWEN_14: 6
            RANGE_REGWEN_15: 6
            RANGE_REGWEN_16: 6
            RANGE_REGWEN_17: 6
            RANGE_REGWEN_18: 6
            RANGE_REGWEN_19: 6
            RANGE_REGWEN_20: 6
            RANGE_REGWEN_21: 6
            RANGE_REGWEN_22: 6
            RANGE_REGWEN_23: 6
            RANGE_REGWEN_24: 6
            RANGE_REGWEN_25: 6
            RANGE_REGWEN_26: 6
            RANGE_REGWEN_27: 6
            RANGE_REGWEN_28: 6
            RANGE_REGWEN_29: 6
            RANGE_REGWEN_30: 6
            RANGE_REGWEN_31: 6
            RANGE_BASE_0: 6
            RANGE_BASE_1: 6
            RANGE_BASE_2: 6
            RANGE_BASE_3: 6
            RANGE_BASE_4: 6
            RANGE_BASE_5: 6
            RANGE_BASE_6: 6
            RANGE_BASE_7: 6
            RANGE_BASE_8: 6
            RANGE_BASE_9: 6
            RANGE_BASE_10: 6
            RANGE_BASE_11: 6
            RANGE_BASE_12: 6
            RANGE_BASE_13: 6
            RANGE_BASE_14: 6
            RANGE_BASE_15: 6
            RANGE_BASE_16: 6
            RANGE_BASE_17: 6
            RANGE_BASE_18: 6
            RANGE_BASE_19: 6
            RANGE_BASE_20: 6
            RANGE_BASE_21: 6
            RANGE_BASE_22: 6
            RANGE_BASE_23: 6
            RANGE_BASE_24: 6
            RANGE_BASE_25: 6
            RANGE_BASE_26: 6
            RANGE_BASE_27: 6
            RANGE_BASE_28: 6
            RANGE_BASE_29: 6
            RANGE_BASE_30: 6
            RANGE_BASE_31: 6
            RANGE_LIMIT_0: 6
            RANGE_LIMIT_1: 6
            RANGE_LIMIT_2: 6
            RANGE_LIMIT_3: 6
            RANGE_LIMIT_4: 6
            RANGE_LIMIT_5: 6
            RANGE_LIMIT_6: 6
            RANGE_LIMIT_7: 6
            RANGE_LIMIT_8: 6
            RANGE_LIMIT_9: 6
            RANGE_LIMIT_10: 6
            RANGE_LIMIT_11: 6
            RANGE_LIMIT_12: 6
            RANGE_LIMIT_13: 6
            RANGE_LIMIT_14: 6
            RANGE_LIMIT_15: 6
            RANGE_LIMIT_16: 6
            RANGE_LIMIT_17: 6
            RANGE_LIMIT_18: 6
            RANGE_LIMIT_19: 6
            RANGE_LIMIT_20: 6
            RANGE_LIMIT_21: 6
            RANGE_LIMIT_22: 6
            RANGE_LIMIT_23: 6
            RANGE_LIMIT_24: 6
            RANGE_LIMIT_25: 6
            RANGE_LIMIT_26: 6
            RANGE_LIMIT_27: 6
            RANGE_LIMIT_28: 6
            RANGE_LIMIT_29: 6
            RANGE_LIMIT_30: 6
            RANGE_LIMIT_31: 6
            RANGE_ATTR_0: 6
            RANGE_ATTR_1: 6
            RANGE_ATTR_2: 6
            RANGE_ATTR_3: 6
            RANGE_ATTR_4: 6
            RANGE_ATTR_5: 6
            RANGE_ATTR_6: 6
            RANGE_ATTR_7: 6
            RANGE_ATTR_8: 6
            RANGE_ATTR_9: 6
            RANGE_ATTR_10: 6
            RANGE_ATTR_11: 6
            RANGE_ATTR_12: 6
            RANGE_ATTR_13: 6
            RANGE_ATTR_14: 6
            RANGE_ATTR_15: 6
            RANGE_ATTR_16: 6
            RANGE_ATTR_17: 6
            RANGE_ATTR_18: 6
            RANGE_ATTR_19: 6
            RANGE_ATTR_20: 6
            RANGE_ATTR_21: 6
            RANGE_ATTR_22: 6
            RANGE_ATTR_23: 6
            RANGE_ATTR_24: 6
            RANGE_ATTR_25: 6
            RANGE_ATTR_26: 6
            RANGE_ATTR_27: 6
            RANGE_ATTR_28: 6
            RANGE_ATTR_29: 6
            RANGE_ATTR_30: 6
            RANGE_ATTR_31: 6
            RANGE_RACL_POLICY_SHADOWED_0: 6
            RANGE_RACL_POLICY_SHADOWED_1: 6
            RANGE_RACL_POLICY_SHADOWED_2: 6
            RANGE_RACL_POLICY_SHADOWED_3: 6
            RANGE_RACL_POLICY_SHADOWED_4: 6
            RANGE_RACL_POLICY_SHADOWED_5: 6
            RANGE_RACL_POLICY_SHADOWED_6: 6
            RANGE_RACL_POLICY_SHADOWED_7: 6
            RANGE_RACL_POLICY_SHADOWED_8: 6
            RANGE_RACL_POLICY_SHADOWED_9: 6
            RANGE_RACL_POLICY_SHADOWED_10: 6
            RANGE_RACL_POLICY_SHADOWED_11: 6
            RANGE_RACL_POLICY_SHADOWED_12: 6
            RANGE_RACL_POLICY_SHADOWED_13: 6
            RANGE_RACL_POLICY_SHADOWED_14: 6
            RANGE_RACL_POLICY_SHADOWED_15: 6
            RANGE_RACL_POLICY_SHADOWED_16: 6
            RANGE_RACL_POLICY_SHADOWED_17: 6
            RANGE_RACL_POLICY_SHADOWED_18: 6
            RANGE_RACL_POLICY_SHADOWED_19: 6
            RANGE_RACL_POLICY_SHADOWED_20: 6
            RANGE_RACL_POLICY_SHADOWED_21: 6
            RANGE_RACL_POLICY_SHADOWED_22: 6
            RANGE_RACL_POLICY_SHADOWED_23: 6
            RANGE_RACL_POLICY_SHADOWED_24: 6
            RANGE_RACL_POLICY_SHADOWED_25: 6
            RANGE_RACL_POLICY_SHADOWED_26: 6
            RANGE_RACL_POLICY_SHADOWED_27: 6
            RANGE_RACL_POLICY_SHADOWED_28: 6
            RANGE_RACL_POLICY_SHADOWED_29: 6
            RANGE_RACL_POLICY_SHADOWED_30: 6
            RANGE_RACL_POLICY_SHADOWED_31: 6
          }
          window_mapping: {}
          range_mapping: []
        }
      }
      domain:
      [
        "0"
      ]
    }
    {
      name: rv_core_ibex_mio
      type: rv_core_ibex_mio
      template_type: rv_core_ibex
      attr: ipgen
      ipgen_params:
      {
        num_regions: 2
        sim_window_address: 0x440
        racl_support: true
      }
      param_decl:
      {
        PMPEnable: "1"
        PMPGranularity: "0"
        PMPNumRegions: "16"
        MHPMCounterNum: "10"
        MHPMCounterWidth: "32"
        PMPRstCfg: ibex_pmp_reset_pkg::MioPmpCfgRst
        PMPRstAddr: ibex_pmp_reset_pkg::MioPmpAddrRst
        PMPRstMsecCfg: ibex_pmp_reset_pkg::MioPmpMseccfgRst
        RV32E: "0"
        RV32M: ibex_pkg::RV32MSingleCycle
        RV32B: ibex_pkg::RV32BOTEarlGrey
        RegFile: ibex_pkg::RegFileFF
        BranchTargetALU: "1"
        WritebackStage: "1"
        ICache: "1"
        ICacheECC: "1"
        ICacheScramble: "1"
        BranchPredictor: "0"
        DbgTriggerEn: "1"
        DbgHwBreakNum: "4"
        SecureIbex: "1"
        DmBaseAddr: tl_mio_main_pkg::ADDR_SPACE_RV_DM__MEM
        DmAddrMask: tl_mio_main_pkg::ADDR_MASK_RV_DM__MEM
        DmHaltAddr: tl_mio_main_pkg::ADDR_SPACE_RV_DM__MEM + dm::HaltAddress[31:0]
        DmExceptionAddr: tl_mio_main_pkg::ADDR_SPACE_RV_DM__MEM + dm::ExceptionAddress[31:0]
        PipeLine: "1"
        InstructionPipeline: "1"
      }
      clock_srcs:
      {
        clk_i: ext_main
        clk_edn_i: ext_main
        clk_esc_i:
        {
          clock: ext_io_div4
          group: secure
        }
        clk_otp_i:
        {
          clock: ext_io_div4
          group: secure
        }
      }
      clock_group: infra
      reset_connections:
      {
        rst_ni:
        {
          name: ext_rst_main
          domain: "0"
        }
        rst_edn_ni:
        {
          name: ext_rst_main
          domain: "0"
        }
        rst_esc_ni:
        {
          name: ext_rst_io_div4
          domain: "0"
        }
        rst_otp_ni:
        {
          name: ext_rst_io_div4
          domain: "0"
        }
      }
      outgoing_alert: mio
      racl_mappings:
      {
        cfg:
        {
          racl_group: mio
          register_mapping:
          {
            ALERT_TEST: 6
            SW_RECOV_ERR: 0
            SW_FATAL_ERR: 0
            IBUS_REGWEN_0: 0
            IBUS_REGWEN_1: 0
            IBUS_ADDR_EN_0: 0
            IBUS_ADDR_EN_1: 0
            IBUS_ADDR_MATCHING_0: 0
            IBUS_ADDR_MATCHING_1: 0
            IBUS_REMAP_ADDR_0: 0
            IBUS_REMAP_ADDR_1: 0
            DBUS_REGWEN_0: 0
            DBUS_REGWEN_1: 0
            DBUS_ADDR_EN_0: 0
            DBUS_ADDR_EN_1: 0
            DBUS_ADDR_MATCHING_0: 0
            DBUS_ADDR_MATCHING_1: 0
            DBUS_REMAP_ADDR_0: 0
            DBUS_REMAP_ADDR_1: 0
            NMI_ENABLE: 0
            NMI_STATE: 0
            ERR_STATUS: 0
            RND_DATA: 0
            RND_STATUS: 0
            FPGA_INFO: 0
          }
          window_mapping:
          {
            DV_SIM_WINDOW: 0
          }
          range_mapping: []
        }
      }
      clock_connections:
      {
        clk_i: clk_ext_main_i
        clk_edn_i: clk_ext_main_i
        clk_esc_i: clk_ext_io_div4_i
        clk_otp_i: clk_ext_io_div4_i
      }
      memory: {}
      param_list:
      [
        {
          name: NEscalationSeverities
          desc: Number of escalation severities
          type: int unsigned
          default: "4"
          local: "false"
          expose: "false"
          name_top: RvCoreIbexMioNEscalationSeverities
        }
        {
          name: WidthPingCounter
          desc: Width of the ping counter
          type: int unsigned
          default: "16"
          local: "false"
          expose: "false"
          name_top: RvCoreIbexMioWidthPingCounter
        }
        {
          name: PMPEnable
          desc: Enable PMP
          type: bit
          default: "1"
          local: "false"
          expose: "true"
          name_top: RvCoreIbexMioPMPEnable
        }
        {
          name: PMPGranularity
          desc: PMP Granularity
          type: int unsigned
          default: "0"
          local: "false"
          expose: "true"
          name_top: RvCoreIbexMioPMPGranularity
        }
        {
          name: PMPNumRegions
          desc: PMP number of regions
          type: int unsigned
          default: "16"
          local: "false"
          expose: "true"
          name_top: RvCoreIbexMioPMPNumRegions
        }
        {
          name: MHPMCounterNum
          desc: "Number of the MHPM counter "
          type: int unsigned
          default: "10"
          local: "false"
          expose: "true"
          name_top: RvCoreIbexMioMHPMCounterNum
        }
        {
          name: MHPMCounterWidth
          desc: "Width of the MHPM Counter "
          type: int unsigned
          default: "32"
          local: "false"
          expose: "true"
          name_top: RvCoreIbexMioMHPMCounterWidth
        }
        {
          name: PMPRstCfg
          desc: Reset value of PMP config CSRs
          type: ibex_pkg::pmp_cfg_t
          unpacked_dimensions: "[16]"
          default: ibex_pmp_reset_pkg::MioPmpCfgRst
          local: "false"
          expose: "true"
          name_top: RvCoreIbexMioPMPRstCfg
        }
        {
          name: PMPRstAddr
          desc: Reset value of PMP address CSRs
          type: logic [33:0]
          unpacked_dimensions: "[16]"
          default: ibex_pmp_reset_pkg::MioPmpAddrRst
          local: "false"
          expose: "true"
          name_top: RvCoreIbexMioPMPRstAddr
        }
        {
          name: PMPRstMsecCfg
          desc: Reset value of MSECCFG CSR
          type: ibex_pkg::pmp_mseccfg_t
          default: ibex_pmp_reset_pkg::MioPmpMseccfgRst
          local: "false"
          expose: "true"
          name_top: RvCoreIbexMioPMPRstMsecCfg
        }
        {
          name: RV32E
          desc: RV32E
          type: bit
          default: "0"
          local: "false"
          expose: "true"
          name_top: RvCoreIbexMioRV32E
        }
        {
          name: RV32M
          desc: RV32M
          type: ibex_pkg::rv32m_e
          default: ibex_pkg::RV32MSingleCycle
          local: "false"
          expose: "true"
          name_top: RvCoreIbexMioRV32M
        }
        {
          name: RV32B
          desc: RV32B
          type: ibex_pkg::rv32b_e
          default: ibex_pkg::RV32BOTEarlGrey
          local: "false"
          expose: "true"
          name_top: RvCoreIbexMioRV32B
        }
        {
          name: RegFile
          desc: Reg file
          type: ibex_pkg::regfile_e
          default: ibex_pkg::RegFileFF
          local: "false"
          expose: "true"
          name_top: RvCoreIbexMioRegFile
        }
        {
          name: BranchTargetALU
          desc: Branch target ALU
          type: bit
          default: "1"
          local: "false"
          expose: "true"
          name_top: RvCoreIbexMioBranchTargetALU
        }
        {
          name: WritebackStage
          desc: Write back stage
          type: bit
          default: "1"
          local: "false"
          expose: "true"
          name_top: RvCoreIbexMioWritebackStage
        }
        {
          name: ICache
          desc: Instruction cache
          type: bit
          default: "1"
          local: "false"
          expose: "true"
          name_top: RvCoreIbexMioICache
        }
        {
          name: ICacheECC
          desc: Instruction cache ECC
          type: bit
          default: "1"
          local: "false"
          expose: "true"
          name_top: RvCoreIbexMioICacheECC
        }
        {
          name: ICacheScramble
          desc: Scramble instruction cach
          type: bit
          default: "1"
          local: "false"
          expose: "true"
          name_top: RvCoreIbexMioICacheScramble
        }
        {
          name: ICacheNWays
          desc: Number of instruction cache ways
          type: int unsigned
          default: 2
          local: "false"
          expose: "true"
          name_top: RvCoreIbexMioICacheNWays
        }
        {
          name: BranchPredictor
          desc: Branch predictor
          type: bit
          default: "0"
          local: "false"
          expose: "true"
          name_top: RvCoreIbexMioBranchPredictor
        }
        {
          name: DbgTriggerEn
          desc: Enable degug trigger
          type: bit
          default: "1"
          local: "false"
          expose: "true"
          name_top: RvCoreIbexMioDbgTriggerEn
        }
        {
          name: DbgHwBreakNum
          desc: Number of debug hardware break
          type: int
          default: "4"
          local: "false"
          expose: "true"
          name_top: RvCoreIbexMioDbgHwBreakNum
        }
        {
          name: SecureIbex
          desc: "Width of the MHPM Counter "
          type: bit
          default: "1"
          local: "false"
          expose: "true"
          name_top: RvCoreIbexMioSecureIbex
        }
        {
          name: DmBaseAddr
          desc: Base address of Debug Module
          type: int unsigned
          default: tl_mio_main_pkg::ADDR_SPACE_RV_DM__MEM
          local: "false"
          expose: "true"
          name_top: RvCoreIbexMioDmBaseAddr
        }
        {
          name: DmAddrMask
          desc: Adress mask of Debug Module
          type: int unsigned
          default: tl_mio_main_pkg::ADDR_MASK_RV_DM__MEM
          local: "false"
          expose: "true"
          name_top: RvCoreIbexMioDmAddrMask
        }
        {
          name: DmHaltAddr
          desc: Halt address
          type: int unsigned
          default: tl_mio_main_pkg::ADDR_SPACE_RV_DM__MEM + dm::HaltAddress[31:0]
          local: "false"
          expose: "true"
          name_top: RvCoreIbexMioDmHaltAddr
        }
        {
          name: DmExceptionAddr
          desc: Exception address
          type: int unsigned
          default: tl_mio_main_pkg::ADDR_SPACE_RV_DM__MEM + dm::ExceptionAddress[31:0]
          local: "false"
          expose: "true"
          name_top: RvCoreIbexMioDmExceptionAddr
        }
        {
          name: PipeLine
          desc: Pipe line
          type: bit
          default: "1"
          local: "false"
          expose: "true"
          name_top: RvCoreIbexMioPipeLine
        }
        {
          name: TlulHostUserRsvdBits
          desc: TLUL user bits sent on outgoing transfers.
          type: logic [tlul_pkg::RsvdWidth-1:0]
          default: "'0"
          local: "false"
          expose: "true"
          name_top: RvCoreIbexMioTlulHostUserRsvdBits
        }
        {
          name: CsrMvendorId
          desc:
            '''
            mvendorid: encoding of manufacturer/provider
            0 indicates this field is not implemented.
            Ibex implementors may wish to set their own JEDEC ID here.
            '''
          type: logic [31:0]
          default: "'0"
          local: "false"
          expose: "true"
          name_top: RvCoreIbexMioCsrMvendorId
        }
        {
          name: CsrMimpId
          desc:
            '''
            mimpid: encoding of processor implementation version
            0 indicates this field is not implemented.
            Ibex implementors may wish to indicate an RTL/netlist version here using their own unique encoding (e.g. 32 bits of the git hash of the implemented commit).
            '''
          type: logic [31:0]
          default: "'0"
          local: "false"
          expose: "true"
          name_top: RvCoreIbexMioCsrMimpId
        }
        {
          name: InstructionPipeline
          desc: Add a pipeline stage in the instruction interface between Ibex and the address translation
          type: bit
          default: "1"
          local: "true"
          expose: "true"
          name_top: RvCoreIbexMioInstructionPipeline
        }
      ]
      inter_signal_list:
      [
        {
          name: rst_cpu_n
          struct: logic
          type: uni
          act: req
          width: 1
          inst_name: rv_core_ibex_mio
          index: -1
        }
        {
          name: ram_cfg_icache_tag
          struct: ram_1p_cfg
          package: prim_ram_1p_pkg
          type: uni
          act: rcv
          width: 1
          inst_name: rv_core_ibex_mio
          index: -1
        }
        {
          name: ram_cfg_rsp_icache_tag
          struct: ram_1p_cfg_rsp
          package: prim_ram_1p_pkg
          type: uni
          act: req
          width:
          {
            name: ICacheNWays
            desc: Number of instruction cache ways
            param_type: int unsigned
            unpacked_dimensions: null
            default: 2
            local: false
            expose: true
            name_top: RvCoreIbexMioICacheNWays
          }
          inst_name: rv_core_ibex_mio
          index: -1
        }
        {
          name: ram_cfg_icache_data
          struct: ram_1p_cfg
          package: prim_ram_1p_pkg
          type: uni
          act: rcv
          width: 1
          inst_name: rv_core_ibex_mio
          index: -1
        }
        {
          name: ram_cfg_rsp_icache_data
          struct: ram_1p_cfg_rsp
          package: prim_ram_1p_pkg
          type: uni
          act: req
          width:
          {
            name: ICacheNWays
            desc: Number of instruction cache ways
            param_type: int unsigned
            unpacked_dimensions: null
            default: 2
            local: false
            expose: true
            name_top: RvCoreIbexMioICacheNWays
          }
          inst_name: rv_core_ibex_mio
          index: -1
        }
        {
          name: hart_id
          struct: logic
          type: uni
          act: rcv
          width: 32
          inst_name: rv_core_ibex_mio
          default: ""
          package: ""
          top_signame: rv_core_ibex_mio_hart_id
          index: -1
        }
        {
          name: boot_addr
          struct: logic
          type: uni
          act: rcv
          width: 32
          inst_name: rv_core_ibex_mio
          default: ""
          package: ""
          external: true
          top_signame: rv_boot_addr
          conn_type: false
          index: -1
        }
        {
          name: irq_software
          struct: logic
          type: uni
          act: rcv
          width: 1
          inst_name: rv_core_ibex_mio
          default: ""
          package: ""
          top_signame: rv_plic_mio_msip
          index: -1
        }
        {
          name: irq_timer
          struct: logic
          type: uni
          act: rcv
          width: 1
          inst_name: rv_core_ibex_mio
          default: ""
          package: ""
          top_signame: rv_core_ibex_mio_irq_timer
          index: -1
        }
        {
          name: irq_external
          struct: logic
          type: uni
          act: rcv
          width: 1
          inst_name: rv_core_ibex_mio
          default: ""
          package: ""
          top_signame: rv_plic_mio_irq
          index: -1
        }
        {
          name: esc_tx
          struct: esc_tx
          package: prim_esc_pkg
          type: uni
          act: rcv
          width: 1
          inst_name: rv_core_ibex_mio
          default: ""
          external: true
          top_signame: rv_core_esc_tx
          conn_type: false
          index: -1
        }
        {
          name: esc_rx
          struct: esc_rx
          package: prim_esc_pkg
          type: uni
          act: req
          width: 1
          inst_name: rv_core_ibex_mio
          default: ""
          external: true
          top_signame: rv_core_esc_rx
          conn_type: false
          index: -1
        }
        {
          name: debug_req
          struct: logic
          type: uni
          act: rcv
          width: 1
          inst_name: rv_core_ibex_mio
          default: ""
          package: ""
          top_signame: rv_dm_debug_req
          index: -1
        }
        {
          name: crash_dump
          struct: cpu_crash_dump
          package: rv_core_ibex_pkg
          type: uni
          act: req
          width: 1
          inst_name: rv_core_ibex_mio
          index: -1
        }
        {
          name: lc_cpu_en
          struct: lc_tx
          package: lc_ctrl_pkg
          type: uni
          act: rcv
          width: 1
          default: lc_ctrl_pkg::On
          inst_name: rv_core_ibex_mio
          external: true
          top_signame: rv_cpu_en
          conn_type: false
          index: -1
        }
        {
          name: pwrmgr_cpu_en
          struct: lc_tx
          package: lc_ctrl_pkg
          type: uni
          act: rcv
          width: 1
          inst_name: rv_core_ibex_mio
          default: ""
          external: true
          top_signame: rv_pwrmgr_cpu_en
          conn_type: false
          index: -1
        }
        {
          name: pwrmgr
          struct: cpu_pwrmgr
          package: rv_core_ibex_pkg
          type: uni
          act: req
          width: 1
          inst_name: rv_core_ibex_mio
          index: -1
        }
        {
          name: nmi_wdog
          struct: logic
          type: uni
          act: rcv
          width: 1
          inst_name: rv_core_ibex_mio
          default: ""
          package: ""
          top_signame: aon_timer_aon_nmi_wdog_timer_bark
          index: -1
        }
        {
          name: edn
          struct: edn
          package: edn_pkg
          type: req_rsp
          act: req
          width: 1
          inst_name: rv_core_ibex_mio
          index: -1
        }
        {
          name: icache_otp_key
          struct: sram_otp_key
          package: otp_ctrl_pkg
          type: req_rsp
          act: req
          width: 1
          inst_name: rv_core_ibex_mio
          index: -1
        }
        {
          name: fpga_info
          struct: logic
          type: uni
          act: rcv
          width: 32
          inst_name: rv_core_ibex_mio
          default: ""
          package: ""
          external: true
          top_signame: fpga_info
          conn_type: false
          index: -1
        }
        {
          name: racl_policies
          desc:
            '''
            Incoming RACL policy vector from a racl_ctrl instance.
            The policy selection vector (parameter) selects the policy for each register.
            '''
          struct: racl_policy_vec
          package: top_racl_pkg
          type: uni
          act: rcv
          width: 1
          inst_name: rv_core_ibex_mio
          default: ""
          top_signame: racl_ctrl_mio_racl_policies
          index: -1
        }
        {
          name: racl_error
          desc: RACL error log information of this module.
          struct: racl_error_log
          package: top_racl_pkg
          type: uni
          act: req
          width: 1
          inst_name: rv_core_ibex_mio
          default: ""
          top_signame: racl_ctrl_mio_racl_error
          index: 16
        }
        {
          name: corei_tl_h
          struct: tl
          package: tlul_pkg
          type: req_rsp
          act: req
          width: 1
          inst_name: rv_core_ibex_mio
          default: ""
          top_signame: mio_main_tl_rv_core_ibex_mio__corei
          index: -1
        }
        {
          name: cored_tl_h
          struct: tl
          package: tlul_pkg
          type: req_rsp
          act: req
          width: 1
          inst_name: rv_core_ibex_mio
          default: ""
          top_signame: mio_main_tl_rv_core_ibex_mio__cored
          index: -1
        }
        {
          name: cfg_tl_d
          struct: tl
          package: tlul_pkg
          type: req_rsp
          act: rsp
          width: 1
          inst_name: rv_core_ibex_mio
          default: ""
          end_idx: -1
          top_signame: rv_core_ibex_mio_cfg_tl_d
          index: -1
        }
      ]
      base_addrs:
      {
        cfg:
        {
          hart: 0x211f0000
        }
      }
      generate_dif: true
      domain:
      [
        "0"
      ]
    }
  ]
  port:
  [
    {}
  ]
  inter_module:
  {
    connect:
    {
      aon_timer_aon.nmi_wdog_timer_bark:
      [
        rv_core_ibex_mio.nmi_wdog
      ]
      dma.lsio_trigger:
      [
        mio_soc_proxy.dma_lsio_trigger
      ]
      rv_plic_mio.msip:
      [
        rv_core_ibex_mio.irq_software
      ]
      rv_plic_mio.irq:
      [
        rv_core_ibex_mio.irq_external
      ]
      rv_dm.debug_req:
      [
        rv_core_ibex_mio.debug_req
      ]
      "mio_soc_proxy.lc_hw_debug_en'":
      [
        rv_dm.lc_hw_debug_en
        sram_ctrl_ret_aon.lc_hw_debug_en
        sram_ctrl_mbox.lc_hw_debug_en
        sram_ctrl_main.lc_hw_debug_en
      ]
      "mio_soc_proxy.lc_escalate_en'":
      [
        rv_dm.lc_escalate_en
        sram_ctrl_ret_aon.lc_escalate_en
        sram_ctrl_mbox.lc_escalate_en
        sram_ctrl_main.lc_escalate_en
        aon_timer_aon.lc_escalate_en
      ]
      sram_ctrl_main.otp_en_sram_ifetch:
      [
        mio_soc_proxy.mubi8_true
      ]
      mio_soc_proxy.dma_tl_h2d:
      [
        dma.ctn_tl_h2d
      ]
      mio_soc_proxy.dma_tl_d2h:
      [
        dma.ctn_tl_d2h
      ]
      mio_soc_proxy.muxed_tl_h2d:
      [
        ac_range_check_mio.ctn_tl_h2d
      ]
      mio_soc_proxy.muxed_tl_d2h:
      [
        ac_range_check_mio.ctn_tl_d2h
      ]
      ac_range_check_mio.ctn_filtered_tl_h2d:
      [
        mio_soc_proxy.ac_range_tl_h2d
      ]
      ac_range_check_mio.ctn_filtered_tl_d2h:
      [
        mio_soc_proxy.ac_range_tl_d2h
      ]
      mio_main.tl_rv_core_ibex_mio__corei:
      [
        rv_core_ibex_mio.corei_tl_h
      ]
      mio_main.tl_rv_core_ibex_mio__cored:
      [
        rv_core_ibex_mio.cored_tl_h
      ]
      mio_main.tl_rv_dm__sba:
      [
        rv_dm.sba_tl_h
      ]
      rv_dm.regs_tl_d:
      [
        mio_main.tl_rv_dm__regs
      ]
      rv_dm.mem_tl_d:
      [
        mio_main.tl_rv_dm__mem
      ]
      mio_main.tl_mio_peri:
      [
        mio_peri.tl_mio_main
      ]
      mio_soc_proxy.ctn_tl:
      [
        mio_main.tl_mio_soc_proxy__ctn
      ]
      rv_plic_mio.tl:
      [
        mio_main.tl_rv_plic_mio
      ]
      rv_core_ibex_mio.cfg_tl_d:
      [
        mio_main.tl_rv_core_ibex_mio__cfg
      ]
      sram_ctrl_main.regs_tl:
      [
        mio_main.tl_sram_ctrl_main__regs
      ]
      sram_ctrl_main.ram_tl:
      [
        mio_main.tl_sram_ctrl_main__ram
      ]
      sram_ctrl_mbox.regs_tl:
      [
        mio_main.tl_sram_ctrl_mbox__regs
      ]
      sram_ctrl_mbox.ram_tl:
      [
        mio_main.tl_sram_ctrl_mbox__ram
      ]
      dma.tl_d:
      [
        mio_main.tl_dma
      ]
      mio_main.tl_dma__host:
      [
        dma.host_tl_h
      ]
      mbx0.core_tl_d:
      [
        mio_main.tl_mbx0__core
      ]
      mio_main.tl_mbx0__sram:
      [
        mbx0.sram_tl_h
      ]
      mbx1.core_tl_d:
      [
        mio_main.tl_mbx1__core
      ]
      mio_main.tl_mbx1__sram:
      [
        mbx1.sram_tl_h
      ]
      mbx2.core_tl_d:
      [
        mio_main.tl_mbx2__core
      ]
      mio_main.tl_mbx2__sram:
      [
        mbx2.sram_tl_h
      ]
      mbx3.core_tl_d:
      [
        mio_main.tl_mbx3__core
      ]
      mio_main.tl_mbx3__sram:
      [
        mbx3.sram_tl_h
      ]
      mbx4.core_tl_d:
      [
        mio_main.tl_mbx4__core
      ]
      mio_main.tl_mbx4__sram:
      [
        mbx4.sram_tl_h
      ]
      mbx5.core_tl_d:
      [
        mio_main.tl_mbx5__core
      ]
      mio_main.tl_mbx5__sram:
      [
        mbx5.sram_tl_h
      ]
      mbx_pcie0.core_tl_d:
      [
        mio_main.tl_mbx_pcie0__core
      ]
      mio_main.tl_mbx_pcie0__sram:
      [
        mbx_pcie0.sram_tl_h
      ]
      rv_timer.tl:
      [
        mio_peri.tl_rv_timer
      ]
      sram_ctrl_ret_aon.regs_tl:
      [
        mio_peri.tl_sram_ctrl_ret_aon__regs
      ]
      sram_ctrl_ret_aon.ram_tl:
      [
        mio_peri.tl_sram_ctrl_ret_aon__ram
      ]
      aon_timer_aon.tl:
      [
        mio_peri.tl_aon_timer_aon
      ]
      mbx0.soc_tl_d:
      [
        mio_mbx.tl_mbx0__soc
      ]
      mbx1.soc_tl_d:
      [
        mio_mbx.tl_mbx1__soc
      ]
      mbx2.soc_tl_d:
      [
        mio_mbx.tl_mbx2__soc
      ]
      mbx3.soc_tl_d:
      [
        mio_mbx.tl_mbx3__soc
      ]
      mbx4.soc_tl_d:
      [
        mio_mbx.tl_mbx4__soc
      ]
      mbx5.soc_tl_d:
      [
        mio_mbx.tl_mbx5__soc
      ]
      mbx_pcie0.soc_tl_d:
      [
        mio_mbx.tl_mbx_pcie0__soc
      ]
      racl_ctrl_mio.tl:
      [
        mio_mbx.tl_racl_ctrl_mio
      ]
      ac_range_check_mio.tl:
      [
        mio_mbx.tl_ac_range_check_mio
      ]
      racl_ctrl_mio.racl_policies:
      [
        rv_timer.racl_policies
        aon_timer_aon.racl_policies
        sram_ctrl_ret_aon.racl_policies
        rv_dm.racl_policies
        rv_plic_mio.racl_policies
        sram_ctrl_main.racl_policies
        sram_ctrl_mbox.racl_policies
        dma.racl_policies
        mbx0.racl_policies
        mbx1.racl_policies
        mbx2.racl_policies
        mbx3.racl_policies
        mbx4.racl_policies
        mbx5.racl_policies
        mbx_pcie0.racl_policies
        ac_range_check_mio.racl_policies
        rv_core_ibex_mio.racl_policies
      ]
      racl_ctrl_mio.racl_error:
      [
        rv_timer.racl_error
        aon_timer_aon.racl_error
        sram_ctrl_ret_aon.racl_error
        rv_dm.racl_error
        rv_plic_mio.racl_error
        sram_ctrl_main.racl_error
        sram_ctrl_mbox.racl_error
        dma.racl_error
        mbx0.racl_error
        mbx1.racl_error
        mbx2.racl_error
        mbx3.racl_error
        mbx4.racl_error
        mbx5.racl_error
        mbx_pcie0.racl_error
        ac_range_check_mio.racl_error
        rv_core_ibex_mio.racl_error
      ]
    }
    top:
    [
      rv_core_ibex_mio.irq_timer
      rv_core_ibex_mio.hart_id
      rv_dm.otp_dis_rv_dm_late_debug
    ]
    external:
    {
      dma.sys: dma_sys
      mio_mbx.tl_mio_mbx: mbx_tl
      rv_dm.next_dm_addr: rv_dm_next_dm_addr
      rv_dm.dbg_tl_d: rv_dm_dbg
      rv_core_ibex_mio.fpga_info: fpga_info
      rv_core_ibex_mio.boot_addr: rv_boot_addr
      rv_core_ibex_mio.pwrmgr_cpu_en: rv_pwrmgr_cpu_en
      rv_core_ibex_mio.lc_cpu_en: rv_cpu_en
      rv_core_ibex_mio.esc_rx: rv_core_esc_rx
      rv_core_ibex_mio.esc_tx: rv_core_esc_tx
      mio_soc_proxy.soc_lsio_trigger: soc_lsio_trigger
      mio_soc_proxy.lc_hw_debug_en_ext: lc_hw_debug_en_ext
      mio_soc_proxy.lc_escalate_en_ext: lc_escalate_en_ext
      mio_soc_proxy.ctn_tl_h2d: ctn_tl_h2d
      mio_soc_proxy.ctn_tl_d2h: ctn_tl_d2h
      mio_soc_proxy.integrator_id: integrator_id
      rv_dm.lc_check_byp_en: lc_check_byp_en
      "rv_dm.strap_en       ": rv_dm_strap_en
      rv_dm.strap_en_override: rv_dm_strap_en_override
      sram_ctrl_ret_aon.cfg: sram_ctrl_ret_aon_ram_1p_cfg
      sram_ctrl_ret_aon.cfg_rsp: sram_ctrl_ret_aon_ram_1p_cfg_rsp
      sram_ctrl_main.cfg: sram_ctrl_main_ram_1p_cfg
      sram_ctrl_main.cfg_rsp: sram_ctrl_main_ram_1p_cfg_rsp
      sram_ctrl_mbox.cfg: sram_ctrl_mbox_ram_1p_cfg
      sram_ctrl_mbox.cfg_rsp: sram_ctrl_mbox_ram_1p_cfg_rsp
      racl_ctrl_mio.racl_policies: racl_policies
      racl_ctrl_mio.racl_error_external: racl_error
      ac_range_check_mio.range_check_overwrite: ac_range_check_overwrite
      aon_timer_aon.aon_timer_rst_req: aon_timer_rst_req
    }
  }
  xbar:
  [
    {
      name: mio_main
      clock_srcs:
      {
        clk_main_i: ext_main
        clk_fixed_i: ext_io_div4
      }
      clock_group: infra
      reset: rst_main_ni
      reset_connections:
      {
        rst_main_ni:
        {
          name: ext_rst_main
          domain: "0"
        }
        rst_fixed_ni:
        {
          name: ext_rst_io_div4
          domain: "0"
        }
      }
      clock_connections:
      {
        clk_main_i: clk_ext_main_i
        clk_fixed_i: clk_ext_io_div4_i
      }
      domain:
      [
        "0"
      ]
      connections:
      {
        rv_core_ibex_mio.corei:
        [
          rv_dm.mem
          sram_ctrl_main.ram
          mio_soc_proxy.ctn
        ]
        rv_core_ibex_mio.cored:
        [
          rv_dm.mem
          rv_dm.regs
          sram_ctrl_main.ram
          mio_peri
          rv_plic_mio
          sram_ctrl_main.regs
          rv_core_ibex_mio.cfg
          sram_ctrl_mbox.ram
          sram_ctrl_mbox.regs
          mio_soc_proxy.ctn
          dma
          mbx0.core
          mbx1.core
          mbx2.core
          mbx3.core
          mbx4.core
          mbx5.core
          mbx_pcie0.core
        ]
        rv_dm.sba:
        [
          rv_dm.mem
          rv_dm.regs
          sram_ctrl_main.ram
          mio_peri
          rv_plic_mio
          sram_ctrl_main.regs
          rv_core_ibex_mio.cfg
          sram_ctrl_mbox.ram
          sram_ctrl_mbox.regs
          mio_soc_proxy.ctn
          dma
          mbx0.core
          mbx1.core
          mbx2.core
          mbx3.core
          mbx4.core
          mbx5.core
          mbx_pcie0.core
        ]
        dma.host:
        [
          sram_ctrl_main.ram
          sram_ctrl_mbox.ram
          mio_soc_proxy.ctn
          mio_peri
        ]
        mbx0.sram:
        [
          sram_ctrl_mbox.ram
        ]
        mbx1.sram:
        [
          sram_ctrl_mbox.ram
        ]
        mbx2.sram:
        [
          sram_ctrl_mbox.ram
        ]
        mbx3.sram:
        [
          sram_ctrl_mbox.ram
        ]
        mbx4.sram:
        [
          sram_ctrl_mbox.ram
        ]
        mbx5.sram:
        [
          sram_ctrl_mbox.ram
        ]
        mbx_pcie0.sram:
        [
          sram_ctrl_mbox.ram
        ]
      }
      nodes:
      [
        {
          name: rv_core_ibex_mio.corei
          type: host
          addr_space: hart
          clock: clk_main_i
          reset: rst_main_ni
          pipeline: false
          xbar: false
          stub: false
          inst_type: ""
          req_fifo_pass: true
          rsp_fifo_pass: true
        }
        {
          name: rv_core_ibex_mio.cored
          type: host
          addr_space: hart
          clock: clk_main_i
          reset: rst_main_ni
          pipeline: false
          xbar: false
          stub: false
          inst_type: ""
          req_fifo_pass: true
          rsp_fifo_pass: true
        }
        {
          name: rv_dm.sba
          type: host
          addr_space: hart
          clock: clk_main_i
          reset: rst_main_ni
          req_fifo_pass: false
          rsp_fifo_pass: false
          xbar: false
          stub: false
          inst_type: ""
          pipeline: true
        }
        {
          name: rv_dm.regs
          type: device
          clock: clk_main_i
          reset: rst_main_ni
          req_fifo_pass: false
          rsp_fifo_pass: false
          inst_type: rv_dm
          addr_range:
          [
            {
              base_addrs:
              {
                hart: 0x21200000
              }
              size_byte: 0x10
            }
          ]
          xbar: false
          stub: false
          pipeline: true
        }
        {
          name: rv_dm.mem
          type: device
          clock: clk_main_i
          reset: rst_main_ni
          req_fifo_pass: false
          rsp_fifo_pass: false
          inst_type: rv_dm
          addr_range:
          [
            {
              base_addrs:
              {
                hart: 0x40000
              }
              size_byte: 0x1000
            }
          ]
          xbar: false
          stub: false
          pipeline: true
        }
        {
          name: mio_peri
          type: device
          clock: clk_fixed_i
          reset: rst_fixed_ni
          req_fifo_pass: false
          rsp_fifo_pass: false
          xbar: true
          stub: false
          pipeline: true
          addr_space: hart
          addr_range:
          [
            {
              base_addrs:
              {
                hart: 0x30000000
              }
              size_byte: 0x800000
            }
          ]
        }
        {
          name: mio_soc_proxy.ctn
          type: device
          clock: clk_main_i
          reset: rst_main_ni
          pipeline: false
          inst_type: mio_soc_proxy
          addr_range:
          [
            {
              base_addrs:
              {
                hart: 0x40000000
              }
              size_byte: 0x80000000
            }
          ]
          xbar: false
          stub: false
          req_fifo_pass: true
        }
        {
          name: rv_plic_mio
          type: device
          clock: clk_main_i
          reset: rst_main_ni
          inst_type: rv_plic_mio
          req_fifo_pass: false
          rsp_fifo_pass: false
          addr_range:
          [
            {
              base_addrs:
              {
                hart: 0x28000000
              }
              size_byte: 0x8000000
            }
          ]
          xbar: false
          stub: false
          pipeline: true
        }
        {
          name: rv_core_ibex_mio.cfg
          type: device
          clock: clk_main_i
          reset: rst_main_ni
          req_fifo_pass: false
          rsp_fifo_pass: false
          inst_type: rv_core_ibex_mio
          addr_range:
          [
            {
              base_addrs:
              {
                hart: 0x211f0000
              }
              size_byte: 0x800
            }
          ]
          xbar: false
          stub: false
          pipeline: true
        }
        {
          name: sram_ctrl_main.regs
          type: device
          clock: clk_main_i
          reset: rst_main_ni
          req_fifo_pass: false
          rsp_fifo_pass: false
          inst_type: sram_ctrl
          addr_range:
          [
            {
              base_addrs:
              {
                hart: 0x211c0000
              }
              size_byte: 0x40
            }
          ]
          xbar: false
          stub: false
          pipeline: true
        }
        {
          name: sram_ctrl_main.ram
          type: device
          clock: clk_main_i
          reset: rst_main_ni
          req_fifo_pass: false
          rsp_fifo_pass: false
          pipeline: true
          inst_type: sram_ctrl
          addr_range:
          [
            {
              base_addrs:
              {
                hart: 0x10000000
              }
              size_byte: 0x10000
            }
          ]
          xbar: false
          stub: false
        }
        {
          name: sram_ctrl_mbox.regs
          type: device
          clock: clk_main_i
          reset: rst_main_ni
          pipeline: false
          inst_type: sram_ctrl
          addr_range:
          [
            {
              base_addrs:
              {
                hart: 0x211d0000
              }
              size_byte: 0x40
            }
          ]
          xbar: false
          stub: false
          req_fifo_pass: true
        }
        {
          name: sram_ctrl_mbox.ram
          type: device
          clock: clk_main_i
          reset: rst_main_ni
          req_fifo_pass: false
          rsp_fifo_pass: false
          pipeline: true
          inst_type: sram_ctrl
          addr_range:
          [
            {
              base_addrs:
              {
                hart: 0x11000000
              }
              size_byte: 0x1000
            }
          ]
          xbar: false
          stub: false
        }
        {
          name: dma
          type: device
          clock: clk_main_i
          reset: rst_main_ni
          req_fifo_pass: false
          rsp_fifo_pass: false
          inst_type: dma
          addr_range:
          [
            {
              base_addrs:
              {
                hart: 0x22010000
              }
              size_byte: 0x200
            }
          ]
          xbar: false
          stub: false
          pipeline: true
        }
        {
          name: dma.host
          type: host
          addr_space: hart
          clock: clk_main_i
          reset: rst_main_ni
          pipeline: false
          xbar: false
          stub: false
          inst_type: ""
          req_fifo_pass: true
          rsp_fifo_pass: true
        }
        {
          name: mbx0.core
          type: device
          addr_space: hart
          clock: clk_main_i
          reset: rst_main_ni
          pipeline: false
          inst_type: mbx
          addr_range:
          [
            {
              base_addrs:
              {
                hart: 0x22000000
              }
              size_byte: 0x80
            }
          ]
          xbar: false
          stub: false
          req_fifo_pass: true
        }
        {
          name: mbx0.sram
          type: host
          addr_space: hart
          clock: clk_main_i
          reset: rst_main_ni
          req_fifo_pass: false
          rsp_fifo_pass: false
          pipeline: true
          xbar: false
          stub: false
          inst_type: ""
        }
        {
          name: mbx1.core
          type: device
          addr_space: hart
          clock: clk_main_i
          reset: rst_main_ni
          pipeline: false
          inst_type: mbx
          addr_range:
          [
            {
              base_addrs:
              {
                hart: 0x22000100
              }
              size_byte: 0x80
            }
          ]
          xbar: false
          stub: false
          req_fifo_pass: true
        }
        {
          name: mbx1.sram
          type: host
          addr_space: hart
          clock: clk_main_i
          reset: rst_main_ni
          req_fifo_pass: false
          rsp_fifo_pass: false
          pipeline: true
          xbar: false
          stub: false
          inst_type: ""
        }
        {
          name: mbx2.core
          type: device
          addr_space: hart
          clock: clk_main_i
          reset: rst_main_ni
          pipeline: false
          inst_type: mbx
          addr_range:
          [
            {
              base_addrs:
              {
                hart: 0x22000200
              }
              size_byte: 0x80
            }
          ]
          xbar: false
          stub: false
          req_fifo_pass: true
        }
        {
          name: mbx2.sram
          type: host
          addr_space: hart
          clock: clk_main_i
          reset: rst_main_ni
          req_fifo_pass: false
          rsp_fifo_pass: false
          pipeline: true
          xbar: false
          stub: false
          inst_type: ""
        }
        {
          name: mbx3.core
          type: device
          addr_space: hart
          clock: clk_main_i
          reset: rst_main_ni
          pipeline: false
          inst_type: mbx
          addr_range:
          [
            {
              base_addrs:
              {
                hart: 0x22000300
              }
              size_byte: 0x80
            }
          ]
          xbar: false
          stub: false
          req_fifo_pass: true
        }
        {
          name: mbx3.sram
          type: host
          addr_space: hart
          clock: clk_main_i
          reset: rst_main_ni
          req_fifo_pass: false
          rsp_fifo_pass: false
          pipeline: true
          xbar: false
          stub: false
          inst_type: ""
        }
        {
          name: mbx4.core
          type: device
          addr_space: hart
          clock: clk_main_i
          reset: rst_main_ni
          pipeline: false
          inst_type: mbx
          addr_range:
          [
            {
              base_addrs:
              {
                hart: 0x22000400
              }
              size_byte: 0x80
            }
          ]
          xbar: false
          stub: false
          req_fifo_pass: true
        }
        {
          name: mbx4.sram
          type: host
          addr_space: hart
          clock: clk_main_i
          reset: rst_main_ni
          req_fifo_pass: false
          rsp_fifo_pass: false
          pipeline: true
          xbar: false
          stub: false
          inst_type: ""
        }
        {
          name: mbx5.core
          type: device
          addr_space: hart
          clock: clk_main_i
          reset: rst_main_ni
          pipeline: false
          inst_type: mbx
          addr_range:
          [
            {
              base_addrs:
              {
                hart: 0x22000500
              }
              size_byte: 0x80
            }
          ]
          xbar: false
          stub: false
          req_fifo_pass: true
        }
        {
          name: mbx5.sram
          type: host
          addr_space: hart
          clock: clk_main_i
          reset: rst_main_ni
          req_fifo_pass: false
          rsp_fifo_pass: false
          pipeline: true
          xbar: false
          stub: false
          inst_type: ""
        }
        {
          name: mbx_pcie0.core
          type: device
          addr_space: hart
          clock: clk_main_i
          reset: rst_main_ni
          pipeline: false
          inst_type: mbx
          addr_range:
          [
            {
              base_addrs:
              {
                hart: 0x22040000
              }
              size_byte: 0x80
            }
          ]
          xbar: false
          stub: false
          req_fifo_pass: true
        }
        {
          name: mbx_pcie0.sram
          type: host
          addr_space: hart
          clock: clk_main_i
          reset: rst_main_ni
          req_fifo_pass: false
          rsp_fifo_pass: false
          pipeline: true
          xbar: false
          stub: false
          inst_type: ""
        }
      ]
      addr_spaces:
      [
        hart
      ]
      clock: clk_main_i
      type: xbar
      inter_signal_list:
      [
        {
          name: tl_rv_core_ibex_mio__corei
          struct: tl
          package: tlul_pkg
          type: req_rsp
          act: rsp
          inst_name: mio_main
          width: 1
          default: ""
          end_idx: -1
          top_signame: mio_main_tl_rv_core_ibex_mio__corei
          index: -1
        }
        {
          name: tl_rv_core_ibex_mio__cored
          struct: tl
          package: tlul_pkg
          type: req_rsp
          act: rsp
          inst_name: mio_main
          width: 1
          default: ""
          end_idx: -1
          top_signame: mio_main_tl_rv_core_ibex_mio__cored
          index: -1
        }
        {
          name: tl_rv_dm__sba
          struct: tl
          package: tlul_pkg
          type: req_rsp
          act: rsp
          inst_name: mio_main
          width: 1
          default: ""
          end_idx: -1
          top_signame: mio_main_tl_rv_dm__sba
          index: -1
        }
        {
          name: tl_dma__host
          struct: tl
          package: tlul_pkg
          type: req_rsp
          act: rsp
          inst_name: mio_main
          width: 1
          default: ""
          end_idx: -1
          top_signame: mio_main_tl_dma__host
          index: -1
        }
        {
          name: tl_mbx0__sram
          struct: tl
          package: tlul_pkg
          type: req_rsp
          act: rsp
          inst_name: mio_main
          width: 1
          default: ""
          end_idx: -1
          top_signame: mio_main_tl_mbx0__sram
          index: -1
        }
        {
          name: tl_mbx1__sram
          struct: tl
          package: tlul_pkg
          type: req_rsp
          act: rsp
          inst_name: mio_main
          width: 1
          default: ""
          end_idx: -1
          top_signame: mio_main_tl_mbx1__sram
          index: -1
        }
        {
          name: tl_mbx2__sram
          struct: tl
          package: tlul_pkg
          type: req_rsp
          act: rsp
          inst_name: mio_main
          width: 1
          default: ""
          end_idx: -1
          top_signame: mio_main_tl_mbx2__sram
          index: -1
        }
        {
          name: tl_mbx3__sram
          struct: tl
          package: tlul_pkg
          type: req_rsp
          act: rsp
          inst_name: mio_main
          width: 1
          default: ""
          end_idx: -1
          top_signame: mio_main_tl_mbx3__sram
          index: -1
        }
        {
          name: tl_mbx4__sram
          struct: tl
          package: tlul_pkg
          type: req_rsp
          act: rsp
          inst_name: mio_main
          width: 1
          default: ""
          end_idx: -1
          top_signame: mio_main_tl_mbx4__sram
          index: -1
        }
        {
          name: tl_mbx5__sram
          struct: tl
          package: tlul_pkg
          type: req_rsp
          act: rsp
          inst_name: mio_main
          width: 1
          default: ""
          end_idx: -1
          top_signame: mio_main_tl_mbx5__sram
          index: -1
        }
        {
          name: tl_mbx_pcie0__sram
          struct: tl
          package: tlul_pkg
          type: req_rsp
          act: rsp
          inst_name: mio_main
          width: 1
          default: ""
          end_idx: -1
          top_signame: mio_main_tl_mbx_pcie0__sram
          index: -1
        }
        {
          name: tl_rv_dm__regs
          struct: tl
          package: tlul_pkg
          type: req_rsp
          act: req
          inst_name: mio_main
          width: 1
          default: ""
          top_signame: rv_dm_regs_tl_d
          index: -1
        }
        {
          name: tl_rv_dm__mem
          struct: tl
          package: tlul_pkg
          type: req_rsp
          act: req
          inst_name: mio_main
          width: 1
          default: ""
          top_signame: rv_dm_mem_tl_d
          index: -1
        }
        {
          name: tl_mio_peri
          struct: tl
          package: tlul_pkg
          type: req_rsp
          act: req
          inst_name: mio_main
          width: 1
          default: ""
          end_idx: -1
          top_signame: mio_main_tl_mio_peri
          index: -1
        }
        {
          name: tl_mio_soc_proxy__ctn
          struct: tl
          package: tlul_pkg
          type: req_rsp
          act: req
          inst_name: mio_main
          width: 1
          default: ""
          top_signame: mio_soc_proxy_ctn_tl
          index: -1
        }
        {
          name: tl_rv_plic_mio
          struct: tl
          package: tlul_pkg
          type: req_rsp
          act: req
          inst_name: mio_main
          width: 1
          default: ""
          top_signame: rv_plic_mio_tl
          index: -1
        }
        {
          name: tl_rv_core_ibex_mio__cfg
          struct: tl
          package: tlul_pkg
          type: req_rsp
          act: req
          inst_name: mio_main
          width: 1
          default: ""
          top_signame: rv_core_ibex_mio_cfg_tl_d
          index: -1
        }
        {
          name: tl_sram_ctrl_main__regs
          struct: tl
          package: tlul_pkg
          type: req_rsp
          act: req
          inst_name: mio_main
          width: 1
          default: ""
          top_signame: sram_ctrl_main_regs_tl
          index: -1
        }
        {
          name: tl_sram_ctrl_main__ram
          struct: tl
          package: tlul_pkg
          type: req_rsp
          act: req
          inst_name: mio_main
          width: 1
          default: ""
          top_signame: sram_ctrl_main_ram_tl
          index: -1
        }
        {
          name: tl_sram_ctrl_mbox__regs
          struct: tl
          package: tlul_pkg
          type: req_rsp
          act: req
          inst_name: mio_main
          width: 1
          default: ""
          top_signame: sram_ctrl_mbox_regs_tl
          index: -1
        }
        {
          name: tl_sram_ctrl_mbox__ram
          struct: tl
          package: tlul_pkg
          type: req_rsp
          act: req
          inst_name: mio_main
          width: 1
          default: ""
          top_signame: sram_ctrl_mbox_ram_tl
          index: -1
        }
        {
          name: tl_dma
          struct: tl
          package: tlul_pkg
          type: req_rsp
          act: req
          inst_name: mio_main
          width: 1
          default: ""
          top_signame: dma_tl_d
          index: -1
        }
        {
          name: tl_mbx0__core
          struct: tl
          package: tlul_pkg
          type: req_rsp
          act: req
          inst_name: mio_main
          width: 1
          default: ""
          top_signame: mbx0_core_tl_d
          index: -1
        }
        {
          name: tl_mbx1__core
          struct: tl
          package: tlul_pkg
          type: req_rsp
          act: req
          inst_name: mio_main
          width: 1
          default: ""
          top_signame: mbx1_core_tl_d
          index: -1
        }
        {
          name: tl_mbx2__core
          struct: tl
          package: tlul_pkg
          type: req_rsp
          act: req
          inst_name: mio_main
          width: 1
          default: ""
          top_signame: mbx2_core_tl_d
          index: -1
        }
        {
          name: tl_mbx3__core
          struct: tl
          package: tlul_pkg
          type: req_rsp
          act: req
          inst_name: mio_main
          width: 1
          default: ""
          top_signame: mbx3_core_tl_d
          index: -1
        }
        {
          name: tl_mbx4__core
          struct: tl
          package: tlul_pkg
          type: req_rsp
          act: req
          inst_name: mio_main
          width: 1
          default: ""
          top_signame: mbx4_core_tl_d
          index: -1
        }
        {
          name: tl_mbx5__core
          struct: tl
          package: tlul_pkg
          type: req_rsp
          act: req
          inst_name: mio_main
          width: 1
          default: ""
          top_signame: mbx5_core_tl_d
          index: -1
        }
        {
          name: tl_mbx_pcie0__core
          struct: tl
          package: tlul_pkg
          type: req_rsp
          act: req
          inst_name: mio_main
          width: 1
          default: ""
          top_signame: mbx_pcie0_core_tl_d
          index: -1
        }
      ]
    }
    {
      name: mio_peri
      clock_srcs:
      {
        clk_peri_i: ext_io_div4
      }
      clock_group: infra
      reset: rst_peri_ni
      reset_connections:
      {
        rst_peri_ni:
        {
          name: ext_rst_io_div4
          domain: "0"
        }
      }
      clock_connections:
      {
        clk_peri_i: clk_ext_io_div4_i
      }
      domain:
      [
        "0"
      ]
      connections:
      {
        mio_main:
        [
          rv_timer
          sram_ctrl_ret_aon.ram
          sram_ctrl_ret_aon.regs
          aon_timer_aon
        ]
      }
      nodes:
      [
        {
          name: mio_main
          type: host
          addr_space: hart
          clock: clk_peri_i
          reset: rst_peri_ni
          xbar: true
          pipeline: false
          stub: false
          inst_type: ""
          req_fifo_pass: true
          rsp_fifo_pass: true
        }
        {
          name: rv_timer
          type: device
          clock: clk_peri_i
          reset: rst_peri_ni
          pipeline: false
          inst_type: rv_timer
          addr_range:
          [
            {
              base_addrs:
              {
                hart: 0x30000000
              }
              size_byte: 0x200
            }
          ]
          xbar: false
          stub: false
          req_fifo_pass: true
        }
        {
          name: sram_ctrl_ret_aon.regs
          type: device
          clock: clk_peri_i
          reset: rst_peri_ni
          pipeline: false
          inst_type: sram_ctrl
          addr_range:
          [
            {
              base_addrs:
              {
                hart: 0x30500000
              }
              size_byte: 0x40
            }
          ]
          xbar: false
          stub: false
          req_fifo_pass: true
        }
        {
          name: sram_ctrl_ret_aon.ram
          type: device
          clock: clk_peri_i
          reset: rst_peri_ni
          pipeline: false
          inst_type: sram_ctrl
          addr_range:
          [
            {
              base_addrs:
              {
                hart: 0x30600000
              }
              size_byte: 0x1000
            }
          ]
          xbar: false
          stub: false
          req_fifo_pass: true
        }
        {
          name: aon_timer_aon
          type: device
          clock: clk_peri_i
          reset: rst_peri_ni
          pipeline: false
          inst_type: aon_timer
          addr_range:
          [
            {
              base_addrs:
              {
                hart: 0x30470000
              }
              size_byte: 0x40
            }
          ]
          xbar: false
          stub: false
          req_fifo_pass: true
        }
      ]
      addr_spaces:
      [
        hart
      ]
      clock: clk_peri_i
      type: xbar
      inter_signal_list:
      [
        {
          name: tl_mio_main
          struct: tl
          package: tlul_pkg
          type: req_rsp
          act: rsp
          inst_name: mio_peri
          width: 1
          default: ""
          top_signame: mio_main_tl_mio_peri
          index: -1
        }
        {
          name: tl_rv_timer
          struct: tl
          package: tlul_pkg
          type: req_rsp
          act: req
          inst_name: mio_peri
          width: 1
          default: ""
          top_signame: rv_timer_tl
          index: -1
        }
        {
          name: tl_sram_ctrl_ret_aon__regs
          struct: tl
          package: tlul_pkg
          type: req_rsp
          act: req
          inst_name: mio_peri
          width: 1
          default: ""
          top_signame: sram_ctrl_ret_aon_regs_tl
          index: -1
        }
        {
          name: tl_sram_ctrl_ret_aon__ram
          struct: tl
          package: tlul_pkg
          type: req_rsp
          act: req
          inst_name: mio_peri
          width: 1
          default: ""
          top_signame: sram_ctrl_ret_aon_ram_tl
          index: -1
        }
        {
          name: tl_aon_timer_aon
          struct: tl
          package: tlul_pkg
          type: req_rsp
          act: req
          inst_name: mio_peri
          width: 1
          default: ""
          top_signame: aon_timer_aon_tl
          index: -1
        }
      ]
    }
    {
      name: mio_mbx
      clock_srcs:
      {
        clk_mbx_i: ext_main
      }
      clock_group: infra
      reset: rst_mbx_ni
      reset_connections:
      {
        rst_mbx_ni:
        {
          name: ext_rst_main
          domain: "0"
        }
      }
      clock_connections:
      {
        clk_mbx_i: clk_ext_main_i
      }
      domain:
      [
        "0"
      ]
      connections:
      {
        mio_mbx:
        [
          mbx0.soc
          mbx1.soc
          mbx2.soc
          mbx3.soc
          mbx4.soc
          mbx5.soc
          mbx_pcie0.soc
          racl_ctrl_mio
          ac_range_check_mio
        ]
      }
      nodes:
      [
        {
          name: mio_mbx
          type: host
          addr_space: soc_mbx
          clock: clk_mbx_i
          reset: rst_mbx_ni
          xbar: true
          pipeline: false
          stub: false
          inst_type: ""
          req_fifo_pass: true
          rsp_fifo_pass: true
        }
        {
          name: mbx0.soc
          type: device
          addr_space: soc_mbx
          clock: clk_mbx_i
          reset: rst_mbx_ni
          req_fifo_pass: false
          rsp_fifo_pass: false
          pipeline: true
          inst_type: mbx
          addr_range:
          [
            {
              base_addrs:
              {
                soc_mbx: 0x1485000
              }
              size_byte: 0x20
            }
          ]
          xbar: false
          stub: false
        }
        {
          name: mbx1.soc
          type: device
          addr_space: soc_mbx
          clock: clk_mbx_i
          reset: rst_mbx_ni
          req_fifo_pass: false
          rsp_fifo_pass: false
          pipeline: true
          inst_type: mbx
          addr_range:
          [
            {
              base_addrs:
              {
                soc_mbx: 0x1485100
              }
              size_byte: 0x20
            }
          ]
          xbar: false
          stub: false
        }
        {
          name: mbx2.soc
          type: device
          addr_space: soc_mbx
          clock: clk_mbx_i
          reset: rst_mbx_ni
          req_fifo_pass: false
          rsp_fifo_pass: false
          pipeline: true
          inst_type: mbx
          addr_range:
          [
            {
              base_addrs:
              {
                soc_mbx: 0x1485200
              }
              size_byte: 0x20
            }
          ]
          xbar: false
          stub: false
        }
        {
          name: mbx3.soc
          type: device
          addr_space: soc_mbx
          clock: clk_mbx_i
          reset: rst_mbx_ni
          req_fifo_pass: false
          rsp_fifo_pass: false
          pipeline: true
          inst_type: mbx
          addr_range:
          [
            {
              base_addrs:
              {
                soc_mbx: 0x1485300
              }
              size_byte: 0x20
            }
          ]
          xbar: false
          stub: false
        }
        {
          name: mbx4.soc
          type: device
          addr_space: soc_mbx
          clock: clk_mbx_i
          reset: rst_mbx_ni
          req_fifo_pass: false
          rsp_fifo_pass: false
          pipeline: true
          inst_type: mbx
          addr_range:
          [
            {
              base_addrs:
              {
                soc_mbx: 0x1485400
              }
              size_byte: 0x20
            }
          ]
          xbar: false
          stub: false
        }
        {
          name: mbx5.soc
          type: device
          addr_space: soc_mbx
          clock: clk_mbx_i
          reset: rst_mbx_ni
          req_fifo_pass: false
          rsp_fifo_pass: false
          pipeline: true
          inst_type: mbx
          addr_range:
          [
            {
              base_addrs:
              {
                soc_mbx: 0x1485500
              }
              size_byte: 0x20
            }
          ]
          xbar: false
          stub: false
        }
        {
          name: mbx_pcie0.soc
          type: device
          addr_space: soc_mbx
          clock: clk_mbx_i
          reset: rst_mbx_ni
          req_fifo_pass: false
          rsp_fifo_pass: false
          pipeline: true
          inst_type: mbx
          addr_range:
          [
            {
              base_addrs:
              {
                soc_mbx: 0x1480100
              }
              size_byte: 0x20
            }
          ]
          xbar: false
          stub: false
        }
        {
          name: racl_ctrl_mio
          type: device
          addr_space: soc_mbx
          clock: clk_mbx_i
          reset: rst_mbx_ni
          req_fifo_pass: false
          rsp_fifo_pass: false
          pipeline: true
          inst_type: racl_ctrl_mio
          addr_range:
          [
            {
              base_addrs:
              {
                soc_mbx: 0x1481f00
              }
              size_byte: 0x100
            }
          ]
          xbar: false
          stub: false
        }
        {
          name: ac_range_check_mio
          type: device
          addr_space: soc_mbx
          clock: clk_mbx_i
          reset: rst_mbx_ni
          req_fifo_pass: false
          rsp_fifo_pass: false
          pipeline: true
          inst_type: ac_range_check_mio
          addr_range:
          [
            {
              base_addrs:
              {
                soc_mbx: 0x1484000
              }
              size_byte: 0x400
            }
          ]
          xbar: false
          stub: false
        }
      ]
      addr_spaces:
      [
        soc_mbx
      ]
      clock: clk_mbx_i
      type: xbar
      inter_signal_list:
      [
        {
          name: tl_mio_mbx
          struct: tl
          package: tlul_pkg
          type: req_rsp
          act: rsp
          inst_name: mio_mbx
          width: 1
          default: ""
          external: true
          top_signame: mbx_tl
          conn_type: false
          index: -1
        }
        {
          name: tl_mbx0__soc
          struct: tl
          package: tlul_pkg
          type: req_rsp
          act: req
          inst_name: mio_mbx
          width: 1
          default: ""
          top_signame: mbx0_soc_tl_d
          index: -1
        }
        {
          name: tl_mbx1__soc
          struct: tl
          package: tlul_pkg
          type: req_rsp
          act: req
          inst_name: mio_mbx
          width: 1
          default: ""
          top_signame: mbx1_soc_tl_d
          index: -1
        }
        {
          name: tl_mbx2__soc
          struct: tl
          package: tlul_pkg
          type: req_rsp
          act: req
          inst_name: mio_mbx
          width: 1
          default: ""
          top_signame: mbx2_soc_tl_d
          index: -1
        }
        {
          name: tl_mbx3__soc
          struct: tl
          package: tlul_pkg
          type: req_rsp
          act: req
          inst_name: mio_mbx
          width: 1
          default: ""
          top_signame: mbx3_soc_tl_d
          index: -1
        }
        {
          name: tl_mbx4__soc
          struct: tl
          package: tlul_pkg
          type: req_rsp
          act: req
          inst_name: mio_mbx
          width: 1
          default: ""
          top_signame: mbx4_soc_tl_d
          index: -1
        }
        {
          name: tl_mbx5__soc
          struct: tl
          package: tlul_pkg
          type: req_rsp
          act: req
          inst_name: mio_mbx
          width: 1
          default: ""
          top_signame: mbx5_soc_tl_d
          index: -1
        }
        {
          name: tl_mbx_pcie0__soc
          struct: tl
          package: tlul_pkg
          type: req_rsp
          act: req
          inst_name: mio_mbx
          width: 1
          default: ""
          top_signame: mbx_pcie0_soc_tl_d
          index: -1
        }
        {
          name: tl_racl_ctrl_mio
          struct: tl
          package: tlul_pkg
          type: req_rsp
          act: req
          inst_name: mio_mbx
          width: 1
          default: ""
          top_signame: racl_ctrl_mio_tl
          index: -1
        }
        {
          name: tl_ac_range_check_mio
          struct: tl
          package: tlul_pkg
          type: req_rsp
          act: req
          inst_name: mio_mbx
          width: 1
          default: ""
          top_signame: ac_range_check_mio_tl
          index: -1
        }
      ]
    }
  ]
  pinout:
  {
    banks:
    [
      VIO
    ]
    pads: []
  }
  pinmux:
  {
    signals: []
    num_wkup_detect: 8
    wkup_cnt_width: 8
    enable_usb_wakeup: false
    enable_strap_sampling: false
  }
  targets: []
  incoming_alert: {}
  incoming_interrupt:
  {
    mio_external:
    [
      {
        name: IPI_FROM_MIO_0
        module_name: MIO_HDR
        type: interrupt
        intr_type: IntrType.Event
        default_val: false
      }
      {
        name: IPI_FROM_MIO_1
        module_name: MIO_HDR
        type: interrupt
        intr_type: IntrType.Event
        default_val: false
      }
      {
        name: IPI_FROM_MIO_2
        module_name: MIO_HDR
        type: interrupt
        intr_type: IntrType.Event
        default_val: false
      }
      {
        name: IPI_FROM_ROT
        module_name: MIO_HDR
        type: interrupt
        intr_type: IntrType.Event
        default_val: false
      }
      {
        name: IPI_FROM_PWC
        module_name: MIO_HDR
        type: interrupt
        intr_type: IntrType.Event
        default_val: false
      }
      {
        name: IPI_FROM_DUC
        module_name: MIO_HDR
        type: interrupt
        intr_type: IntrType.Event
        default_val: false
      }
      {
        name: IBEX_IRQ
        module_name: LIO_GRP_A
        type: interrupt
        intr_type: IntrType.Event
        default_val: false
      }
      {
        name: IBEX_IRQ
        module_name: LIO_GRP_B
        type: interrupt
        intr_type: IntrType.Event
        default_val: false
      }
      {
        name: IBEX_IRQ
        module_name: LIO_GRP_C
        type: interrupt
        intr_type: IntrType.Event
        default_val: false
      }
    ]
  }
  exported_clks: {}
  racl:
  {
    error_response: false
    ctn_uid_bit_lsb: 0
    ctn_uid_bit_msb: 4
    role_bit_lsb: 5
    role_bit_msb: 8
    roles:
    {
      NOT_TEE:
      {
        role_id: 0
      }
      M_MODE:
      {
        role_id: 1
      }
      TEE_MODE:
      {
        role_id: 2
      }
      R_CODE:
      {
        role_id: 3
      }
      CAT2_DEBUG:
      {
        role_id: 4
      }
      CAT3_DEBUG:
      {
        role_id: 5
      }
      ROT:
      {
        role_id: 6
      }
      MIO:
      {
        role_id: 7
      }
      PWC:
      {
        role_id: 8
      }
      INT_SOC:
      {
        role_id: 9
      }
      IO_AGENT:
      {
        role_id: 10
      }
      TEE_IO_AGENT:
      {
        role_id: 11
      }
      DUC_UC:
      {
        role_id: 12
      }
      MIMT_R_MODE:
      {
        role_id: 13
      }
    }
    policies:
    {
      Null:
      [
        {
          name: all_rd_wr_policy
          allowed_wr:
          [
            NOT_TEE
            M_MODE
            TEE_MODE
            R_CODE
            CAT2_DEBUG
            CAT3_DEBUG
            ROT
            MIO
            PWC
            INT_SOC
            IO_AGENT
            TEE_IO_AGENT
            DUC_UC
            MIMT_R_MODE
          ]
          allowed_rd:
          [
            NOT_TEE
            M_MODE
            TEE_MODE
            R_CODE
            CAT2_DEBUG
            CAT3_DEBUG
            ROT
            MIO
            PWC
            INT_SOC
            IO_AGENT
            TEE_IO_AGENT
            DUC_UC
            MIMT_R_MODE
          ]
          rd_default: 16383
          wr_default: 16383
        }
        {
          name: hw_rot_pwc_wr_all_rd_policy
          allowed_wr:
          [
            CAT3_DEBUG
            ROT
            PWC
            INT_SOC
          ]
          allowed_rd:
          [
            NOT_TEE
            M_MODE
            TEE_MODE
            R_CODE
            CAT2_DEBUG
            CAT3_DEBUG
            ROT
            MIO
            PWC
            INT_SOC
            IO_AGENT
            TEE_IO_AGENT
            DUC_UC
            MIMT_R_MODE
          ]
          rd_default: 16383
          wr_default: 864
        }
        {
          name: pre_boot_m_policy
          allowed_wr:
          [
            M_MODE
            R_CODE
            CAT2_DEBUG
            CAT3_DEBUG
            ROT
            PWC
            INT_SOC
          ]
          allowed_rd:
          [
            NOT_TEE
            M_MODE
            TEE_MODE
            R_CODE
            CAT2_DEBUG
            CAT3_DEBUG
            ROT
            MIO
            PWC
            INT_SOC
          ]
          rd_default: 1023
          wr_default: 890
        }
        {
          name: post_boot_m_policy
          allowed_wr:
          [
            M_MODE
            R_CODE
            CAT2_DEBUG
            CAT3_DEBUG
            ROT
            PWC
            INT_SOC
          ]
          allowed_rd:
          [
            NOT_TEE
            M_MODE
            TEE_MODE
            R_CODE
            CAT2_DEBUG
            CAT3_DEBUG
            ROT
            MIO
            PWC
            INT_SOC
          ]
          rd_default: 1023
          wr_default: 890
        }
        {
          name: tee_limited_policy
          allowed_wr:
          [
            TEE_MODE
            R_CODE
            CAT2_DEBUG
            CAT3_DEBUG
            ROT
            PWC
            INT_SOC
            TEE_IO_AGENT
          ]
          allowed_rd:
          [
            TEE_MODE
            R_CODE
            CAT2_DEBUG
            CAT3_DEBUG
            ROT
            PWC
            INT_SOC
            TEE_IO_AGENT
          ]
          rd_default: 2940
          wr_default: 2940
        }
        {
          name: rcode_private_policy
          allowed_wr:
          [
            R_CODE
            CAT3_DEBUG
            ROT
            PWC
            INT_SOC
          ]
          allowed_rd:
          [
            R_CODE
            CAT3_DEBUG
            ROT
            PWC
            INT_SOC
          ]
          rd_default: 872
          wr_default: 872
        }
        {
          name: rot_private_policy
          rot_private: true
          allowed_wr:
          [
            CAT3_DEBUG
            ROT
          ]
          allowed_rd:
          [
            CAT3_DEBUG
            ROT
          ]
          rd_default: 96
          wr_default: 96
        }
        {
          name: pwc_private_policy
          allowed_wr:
          [
            CAT3_DEBUG
            ROT
            PWC
            INT_SOC
          ]
          allowed_rd:
          [
            CAT3_DEBUG
            ROT
            PWC
            INT_SOC
          ]
          rd_default: 864
          wr_default: 864
        }
        {
          name: mio_private_policy
          allowed_wr:
          [
            CAT3_DEBUG
            ROT
            MIO
            PWC
            INT_SOC
          ]
          allowed_rd:
          [
            CAT3_DEBUG
            ROT
            MIO
            PWC
            INT_SOC
          ]
          rd_default: 992
          wr_default: 992
        }
        {
          name: duc_private_policy
          allowed_wr:
          [
            CAT3_DEBUG
            ROT
            PWC
            INT_SOC
            DUC_UC
            MIMT_R_MODE
          ]
          allowed_rd:
          [
            CAT3_DEBUG
            ROT
            PWC
            INT_SOC
            DUC_UC
            MIMT_R_MODE
          ]
          rd_default: 13152
          wr_default: 13152
        }
      ]
      rot:
      [
        {
          name: all_rd_wr_policy
          allowed_wr:
          [
            NOT_TEE
            M_MODE
            TEE_MODE
            R_CODE
            CAT2_DEBUG
            CAT3_DEBUG
            ROT
            MIO
            PWC
            INT_SOC
            IO_AGENT
            TEE_IO_AGENT
            DUC_UC
            MIMT_R_MODE
          ]
          allowed_rd:
          [
            NOT_TEE
            M_MODE
            TEE_MODE
            R_CODE
            CAT2_DEBUG
            CAT3_DEBUG
            ROT
            MIO
            PWC
            INT_SOC
            IO_AGENT
            TEE_IO_AGENT
            DUC_UC
            MIMT_R_MODE
          ]
          rd_default: 16383
          wr_default: 16383
        }
        {
          name: hw_rot_pwc_wr_all_rd_policy
          allowed_wr:
          [
            CAT3_DEBUG
            ROT
            PWC
            INT_SOC
          ]
          allowed_rd:
          [
            NOT_TEE
            M_MODE
            TEE_MODE
            R_CODE
            CAT2_DEBUG
            CAT3_DEBUG
            ROT
            MIO
            PWC
            INT_SOC
            IO_AGENT
            TEE_IO_AGENT
            DUC_UC
            MIMT_R_MODE
          ]
          rd_default: 16383
          wr_default: 864
        }
        {
          name: pre_boot_m_policy
          allowed_wr:
          [
            M_MODE
            R_CODE
            CAT2_DEBUG
            CAT3_DEBUG
            ROT
            PWC
            INT_SOC
          ]
          allowed_rd:
          [
            NOT_TEE
            M_MODE
            TEE_MODE
            R_CODE
            CAT2_DEBUG
            CAT3_DEBUG
            ROT
            MIO
            PWC
            INT_SOC
          ]
          rd_default: 1023
          wr_default: 890
        }
        {
          name: post_boot_m_policy
          allowed_wr:
          [
            M_MODE
            R_CODE
            CAT2_DEBUG
            CAT3_DEBUG
            ROT
            PWC
            INT_SOC
          ]
          allowed_rd:
          [
            NOT_TEE
            M_MODE
            TEE_MODE
            R_CODE
            CAT2_DEBUG
            CAT3_DEBUG
            ROT
            MIO
            PWC
            INT_SOC
          ]
          rd_default: 1023
          wr_default: 890
        }
        {
          name: tee_limited_policy
          allowed_wr:
          [
            TEE_MODE
            R_CODE
            CAT2_DEBUG
            CAT3_DEBUG
            ROT
            PWC
            INT_SOC
            TEE_IO_AGENT
          ]
          allowed_rd:
          [
            TEE_MODE
            R_CODE
            CAT2_DEBUG
            CAT3_DEBUG
            ROT
            PWC
            INT_SOC
            TEE_IO_AGENT
          ]
          rd_default: 2940
          wr_default: 2940
        }
        {
          name: rcode_private_policy
          allowed_wr:
          [
            R_CODE
            CAT3_DEBUG
            ROT
            PWC
            INT_SOC
          ]
          allowed_rd:
          [
            R_CODE
            CAT3_DEBUG
            ROT
            PWC
            INT_SOC
          ]
          rd_default: 872
          wr_default: 872
        }
        {
          name: rot_private_policy
          allowed_wr:
          [
            CAT3_DEBUG
            ROT
          ]
          allowed_rd:
          [
            CAT3_DEBUG
            ROT
          ]
          rd_default: 96
          wr_default: 96
        }
        {
          name: pwc_private_policy
          allowed_wr:
          [
            CAT3_DEBUG
            ROT
            PWC
            INT_SOC
          ]
          allowed_rd:
          [
            CAT3_DEBUG
            ROT
            PWC
            INT_SOC
          ]
          rd_default: 864
          wr_default: 864
        }
        {
          name: mio_private_policy
          allowed_wr:
          [
            CAT3_DEBUG
            ROT
            MIO
            PWC
            INT_SOC
          ]
          allowed_rd:
          [
            CAT3_DEBUG
            ROT
            MIO
            PWC
            INT_SOC
          ]
          rd_default: 992
          wr_default: 992
        }
        {
          name: duc_private_policy
          allowed_wr:
          [
            CAT3_DEBUG
            ROT
            PWC
            INT_SOC
            DUC_UC
            MIMT_R_MODE
          ]
          allowed_rd:
          [
            CAT3_DEBUG
            ROT
            PWC
            INT_SOC
            DUC_UC
            MIMT_R_MODE
          ]
          rd_default: 13152
          wr_default: 13152
        }
      ]
      pwc:
      [
        {
          name: all_rd_wr_policy
          allowed_wr:
          [
            NOT_TEE
            M_MODE
            TEE_MODE
            R_CODE
            CAT2_DEBUG
            CAT3_DEBUG
            ROT
            MIO
            PWC
            INT_SOC
            IO_AGENT
            TEE_IO_AGENT
            DUC_UC
            MIMT_R_MODE
          ]
          allowed_rd:
          [
            NOT_TEE
            M_MODE
            TEE_MODE
            R_CODE
            CAT2_DEBUG
            CAT3_DEBUG
            ROT
            MIO
            PWC
            INT_SOC
            IO_AGENT
            TEE_IO_AGENT
            DUC_UC
            MIMT_R_MODE
          ]
          rd_default: 16383
          wr_default: 16383
        }
        {
          name: hw_rot_pwc_wr_all_rd_policy
          allowed_wr:
          [
            CAT3_DEBUG
            ROT
            PWC
            INT_SOC
          ]
          allowed_rd:
          [
            NOT_TEE
            M_MODE
            TEE_MODE
            R_CODE
            CAT2_DEBUG
            CAT3_DEBUG
            ROT
            MIO
            PWC
            INT_SOC
            IO_AGENT
            TEE_IO_AGENT
            DUC_UC
            MIMT_R_MODE
          ]
          rd_default: 16383
          wr_default: 864
        }
        {
          name: pre_boot_m_policy
          allowed_wr:
          [
            M_MODE
            R_CODE
            CAT2_DEBUG
            CAT3_DEBUG
            ROT
            PWC
            INT_SOC
          ]
          allowed_rd:
          [
            NOT_TEE
            M_MODE
            TEE_MODE
            R_CODE
            CAT2_DEBUG
            CAT3_DEBUG
            ROT
            MIO
            PWC
            INT_SOC
          ]
          rd_default: 1023
          wr_default: 890
        }
        {
          name: post_boot_m_policy
          allowed_wr:
          [
            M_MODE
            R_CODE
            CAT2_DEBUG
            CAT3_DEBUG
            ROT
            PWC
            INT_SOC
          ]
          allowed_rd:
          [
            NOT_TEE
            M_MODE
            TEE_MODE
            R_CODE
            CAT2_DEBUG
            CAT3_DEBUG
            ROT
            MIO
            PWC
            INT_SOC
          ]
          rd_default: 1023
          wr_default: 890
        }
        {
          name: tee_limited_policy
          allowed_wr:
          [
            TEE_MODE
            R_CODE
            CAT2_DEBUG
            CAT3_DEBUG
            ROT
            PWC
            INT_SOC
            TEE_IO_AGENT
          ]
          allowed_rd:
          [
            TEE_MODE
            R_CODE
            CAT2_DEBUG
            CAT3_DEBUG
            ROT
            PWC
            INT_SOC
            TEE_IO_AGENT
          ]
          rd_default: 2940
          wr_default: 2940
        }
        {
          name: rcode_private_policy
          allowed_wr:
          [
            R_CODE
            CAT3_DEBUG
            ROT
            PWC
            INT_SOC
          ]
          allowed_rd:
          [
            R_CODE
            CAT3_DEBUG
            ROT
            PWC
            INT_SOC
          ]
          rd_default: 872
          wr_default: 872
        }
        {
          name: rot_private_policy
          allowed_wr:
          [
            CAT3_DEBUG
            ROT
          ]
          allowed_rd:
          [
            CAT3_DEBUG
            ROT
          ]
          rd_default: 96
          wr_default: 96
        }
        {
          name: pwc_private_policy
          allowed_wr:
          [
            CAT3_DEBUG
            ROT
            PWC
            INT_SOC
          ]
          allowed_rd:
          [
            CAT3_DEBUG
            ROT
            PWC
            INT_SOC
          ]
          rd_default: 864
          wr_default: 864
        }
        {
          name: mio_private_policy
          allowed_wr:
          [
            CAT3_DEBUG
            ROT
            MIO
            PWC
            INT_SOC
          ]
          allowed_rd:
          [
            CAT3_DEBUG
            ROT
            MIO
            PWC
            INT_SOC
          ]
          rd_default: 992
          wr_default: 992
        }
        {
          name: duc_private_policy
          allowed_wr:
          [
            CAT3_DEBUG
            ROT
            PWC
            INT_SOC
            DUC_UC
            MIMT_R_MODE
          ]
          allowed_rd:
          [
            CAT3_DEBUG
            ROT
            PWC
            INT_SOC
            DUC_UC
            MIMT_R_MODE
          ]
          rd_default: 13152
          wr_default: 13152
        }
      ]
      mio:
      [
        {
          name: all_rd_wr_policy
          allowed_wr:
          [
            NOT_TEE
            M_MODE
            TEE_MODE
            R_CODE
            CAT2_DEBUG
            CAT3_DEBUG
            ROT
            MIO
            PWC
            INT_SOC
            IO_AGENT
            TEE_IO_AGENT
            DUC_UC
            MIMT_R_MODE
          ]
          allowed_rd:
          [
            NOT_TEE
            M_MODE
            TEE_MODE
            R_CODE
            CAT2_DEBUG
            CAT3_DEBUG
            ROT
            MIO
            PWC
            INT_SOC
            IO_AGENT
            TEE_IO_AGENT
            DUC_UC
            MIMT_R_MODE
          ]
          rd_default: 16383
          wr_default: 16383
        }
        {
          name: hw_rot_pwc_wr_all_rd_policy
          allowed_wr:
          [
            CAT3_DEBUG
            ROT
            PWC
            INT_SOC
          ]
          allowed_rd:
          [
            NOT_TEE
            M_MODE
            TEE_MODE
            R_CODE
            CAT2_DEBUG
            CAT3_DEBUG
            ROT
            MIO
            PWC
            INT_SOC
            IO_AGENT
            TEE_IO_AGENT
            DUC_UC
            MIMT_R_MODE
          ]
          rd_default: 16383
          wr_default: 864
        }
        {
          name: pre_boot_m_policy
          allowed_wr:
          [
            M_MODE
            R_CODE
            CAT2_DEBUG
            CAT3_DEBUG
            ROT
            PWC
            INT_SOC
          ]
          allowed_rd:
          [
            NOT_TEE
            M_MODE
            TEE_MODE
            R_CODE
            CAT2_DEBUG
            CAT3_DEBUG
            ROT
            MIO
            PWC
            INT_SOC
          ]
          rd_default: 1023
          wr_default: 890
        }
        {
          name: post_boot_m_policy
          allowed_wr:
          [
            M_MODE
            R_CODE
            CAT2_DEBUG
            CAT3_DEBUG
            ROT
            PWC
            INT_SOC
          ]
          allowed_rd:
          [
            NOT_TEE
            M_MODE
            TEE_MODE
            R_CODE
            CAT2_DEBUG
            CAT3_DEBUG
            ROT
            MIO
            PWC
            INT_SOC
          ]
          rd_default: 1023
          wr_default: 890
        }
        {
          name: tee_limited_policy
          allowed_wr:
          [
            TEE_MODE
            R_CODE
            CAT2_DEBUG
            CAT3_DEBUG
            ROT
            PWC
            INT_SOC
            TEE_IO_AGENT
          ]
          allowed_rd:
          [
            TEE_MODE
            R_CODE
            CAT2_DEBUG
            CAT3_DEBUG
            ROT
            PWC
            INT_SOC
            TEE_IO_AGENT
          ]
          rd_default: 2940
          wr_default: 2940
        }
        {
          name: rcode_private_policy
          allowed_wr:
          [
            R_CODE
            CAT3_DEBUG
            ROT
            PWC
            INT_SOC
          ]
          allowed_rd:
          [
            R_CODE
            CAT3_DEBUG
            ROT
            PWC
            INT_SOC
          ]
          rd_default: 872
          wr_default: 872
        }
        {
          name: rot_private_policy
          allowed_wr:
          [
            CAT3_DEBUG
            ROT
          ]
          allowed_rd:
          [
            CAT3_DEBUG
            ROT
          ]
          rd_default: 96
          wr_default: 96
        }
        {
          name: pwc_private_policy
          allowed_wr:
          [
            CAT3_DEBUG
            ROT
            PWC
            INT_SOC
          ]
          allowed_rd:
          [
            CAT3_DEBUG
            ROT
            PWC
            INT_SOC
          ]
          rd_default: 864
          wr_default: 864
        }
        {
          name: mio_private_policy
          allowed_wr:
          [
            CAT3_DEBUG
            ROT
            MIO
            PWC
            INT_SOC
          ]
          allowed_rd:
          [
            CAT3_DEBUG
            ROT
            MIO
            PWC
            INT_SOC
          ]
          rd_default: 992
          wr_default: 992
        }
        {
          name: duc_private_policy
          allowed_wr:
          [
            CAT3_DEBUG
            ROT
            PWC
            INT_SOC
            DUC_UC
            MIMT_R_MODE
          ]
          allowed_rd:
          [
            CAT3_DEBUG
            ROT
            PWC
            INT_SOC
            DUC_UC
            MIMT_R_MODE
          ]
          rd_default: 13152
          wr_default: 13152
        }
      ]
      nsEfuse:
      [
        {
          name: all_rd_wr_policy
          allowed_wr:
          [
            NOT_TEE
            M_MODE
            TEE_MODE
            R_CODE
            CAT2_DEBUG
            CAT3_DEBUG
            ROT
            MIO
            PWC
            INT_SOC
            IO_AGENT
            TEE_IO_AGENT
            DUC_UC
            MIMT_R_MODE
          ]
          allowed_rd:
          [
            NOT_TEE
            M_MODE
            TEE_MODE
            R_CODE
            CAT2_DEBUG
            CAT3_DEBUG
            ROT
            MIO
            PWC
            INT_SOC
            IO_AGENT
            TEE_IO_AGENT
            DUC_UC
            MIMT_R_MODE
          ]
          rd_default: 16383
          wr_default: 16383
        }
        {
          name: hw_rot_pwc_wr_all_rd_policy
          allowed_wr:
          [
            CAT3_DEBUG
            ROT
            PWC
            INT_SOC
          ]
          allowed_rd:
          [
            NOT_TEE
            M_MODE
            TEE_MODE
            R_CODE
            CAT2_DEBUG
            CAT3_DEBUG
            ROT
            MIO
            PWC
            INT_SOC
            IO_AGENT
            TEE_IO_AGENT
            DUC_UC
            MIMT_R_MODE
          ]
          rd_default: 16383
          wr_default: 864
        }
        {
          name: pre_boot_m_policy
          allowed_wr:
          [
            M_MODE
            R_CODE
            CAT2_DEBUG
            CAT3_DEBUG
            ROT
            PWC
            INT_SOC
          ]
          allowed_rd:
          [
            NOT_TEE
            M_MODE
            TEE_MODE
            R_CODE
            CAT2_DEBUG
            CAT3_DEBUG
            ROT
            MIO
            PWC
            INT_SOC
          ]
          rd_default: 1023
          wr_default: 890
        }
        {
          name: post_boot_m_policy
          allowed_wr:
          [
            M_MODE
            R_CODE
            CAT2_DEBUG
            CAT3_DEBUG
            ROT
            PWC
            INT_SOC
          ]
          allowed_rd:
          [
            NOT_TEE
            M_MODE
            TEE_MODE
            R_CODE
            CAT2_DEBUG
            CAT3_DEBUG
            ROT
            MIO
            PWC
            INT_SOC
          ]
          rd_default: 1023
          wr_default: 890
        }
        {
          name: tee_limited_policy
          allowed_wr:
          [
            TEE_MODE
            R_CODE
            CAT2_DEBUG
            CAT3_DEBUG
            ROT
            PWC
            INT_SOC
            TEE_IO_AGENT
          ]
          allowed_rd:
          [
            TEE_MODE
            R_CODE
            CAT2_DEBUG
            CAT3_DEBUG
            ROT
            PWC
            INT_SOC
            TEE_IO_AGENT
          ]
          rd_default: 2940
          wr_default: 2940
        }
        {
          name: rcode_private_policy
          allowed_wr:
          [
            R_CODE
            CAT3_DEBUG
            ROT
            PWC
            INT_SOC
          ]
          allowed_rd:
          [
            R_CODE
            CAT3_DEBUG
            ROT
            PWC
            INT_SOC
          ]
          rd_default: 872
          wr_default: 872
        }
        {
          name: rot_private_policy
          allowed_wr:
          [
            CAT3_DEBUG
            ROT
          ]
          allowed_rd:
          [
            CAT3_DEBUG
            ROT
          ]
          rd_default: 96
          wr_default: 96
        }
        {
          name: pwc_private_policy
          allowed_wr:
          [
            CAT3_DEBUG
            ROT
            PWC
            INT_SOC
          ]
          allowed_rd:
          [
            CAT3_DEBUG
            ROT
            PWC
            INT_SOC
          ]
          rd_default: 864
          wr_default: 864
        }
        {
          name: mio_private_policy
          allowed_wr:
          [
            CAT3_DEBUG
            ROT
            MIO
            PWC
            INT_SOC
          ]
          allowed_rd:
          [
            CAT3_DEBUG
            ROT
            MIO
            PWC
            INT_SOC
          ]
          rd_default: 992
          wr_default: 992
        }
        {
          name: duc_private_policy
          allowed_wr:
          [
            CAT3_DEBUG
            ROT
            PWC
            INT_SOC
            DUC_UC
            MIMT_R_MODE
          ]
          allowed_rd:
          [
            CAT3_DEBUG
            ROT
            PWC
            INT_SOC
            DUC_UC
            MIMT_R_MODE
          ]
          rd_default: 13152
          wr_default: 13152
        }
      ]
      lioGrpV:
      [
        {
          name: all_rd_wr_policy
          allowed_wr:
          [
            NOT_TEE
            M_MODE
            TEE_MODE
            R_CODE
            CAT2_DEBUG
            CAT3_DEBUG
            ROT
            MIO
            PWC
            INT_SOC
            IO_AGENT
            TEE_IO_AGENT
            DUC_UC
            MIMT_R_MODE
          ]
          allowed_rd:
          [
            NOT_TEE
            M_MODE
            TEE_MODE
            R_CODE
            CAT2_DEBUG
            CAT3_DEBUG
            ROT
            MIO
            PWC
            INT_SOC
            IO_AGENT
            TEE_IO_AGENT
            DUC_UC
            MIMT_R_MODE
          ]
          rd_default: 16383
          wr_default: 16383
        }
        {
          name: hw_rot_pwc_wr_all_rd_policy
          allowed_wr:
          [
            CAT3_DEBUG
            ROT
            PWC
            INT_SOC
          ]
          allowed_rd:
          [
            NOT_TEE
            M_MODE
            TEE_MODE
            R_CODE
            CAT2_DEBUG
            CAT3_DEBUG
            ROT
            MIO
            PWC
            INT_SOC
            IO_AGENT
            TEE_IO_AGENT
            DUC_UC
            MIMT_R_MODE
          ]
          rd_default: 16383
          wr_default: 864
        }
        {
          name: pre_boot_m_policy
          allowed_wr:
          [
            M_MODE
            R_CODE
            CAT2_DEBUG
            CAT3_DEBUG
            ROT
            PWC
            INT_SOC
          ]
          allowed_rd:
          [
            NOT_TEE
            M_MODE
            TEE_MODE
            R_CODE
            CAT2_DEBUG
            CAT3_DEBUG
            ROT
            MIO
            PWC
            INT_SOC
          ]
          rd_default: 1023
          wr_default: 890
        }
        {
          name: post_boot_m_policy
          allowed_wr:
          [
            M_MODE
            R_CODE
            CAT2_DEBUG
            CAT3_DEBUG
            ROT
            PWC
            INT_SOC
          ]
          allowed_rd:
          [
            NOT_TEE
            M_MODE
            TEE_MODE
            R_CODE
            CAT2_DEBUG
            CAT3_DEBUG
            ROT
            MIO
            PWC
            INT_SOC
          ]
          rd_default: 1023
          wr_default: 890
        }
        {
          name: tee_limited_policy
          allowed_wr:
          [
            TEE_MODE
            R_CODE
            CAT2_DEBUG
            CAT3_DEBUG
            ROT
            PWC
            INT_SOC
            TEE_IO_AGENT
          ]
          allowed_rd:
          [
            TEE_MODE
            R_CODE
            CAT2_DEBUG
            CAT3_DEBUG
            ROT
            PWC
            INT_SOC
            TEE_IO_AGENT
          ]
          rd_default: 2940
          wr_default: 2940
        }
        {
          name: rcode_private_policy
          allowed_wr:
          [
            R_CODE
            CAT3_DEBUG
            ROT
            PWC
            INT_SOC
          ]
          allowed_rd:
          [
            R_CODE
            CAT3_DEBUG
            ROT
            PWC
            INT_SOC
          ]
          rd_default: 872
          wr_default: 872
        }
        {
          name: rot_private_policy
          allowed_wr:
          [
            CAT3_DEBUG
            ROT
          ]
          allowed_rd:
          [
            CAT3_DEBUG
            ROT
          ]
          rd_default: 96
          wr_default: 96
        }
        {
          name: pwc_private_policy
          allowed_wr:
          [
            CAT3_DEBUG
            ROT
            PWC
            INT_SOC
          ]
          allowed_rd:
          [
            CAT3_DEBUG
            ROT
            PWC
            INT_SOC
          ]
          rd_default: 864
          wr_default: 864
        }
        {
          name: mio_private_policy
          allowed_wr:
          [
            CAT3_DEBUG
            ROT
            MIO
            PWC
            INT_SOC
          ]
          allowed_rd:
          [
            CAT3_DEBUG
            ROT
            MIO
            PWC
            INT_SOC
          ]
          rd_default: 992
          wr_default: 992
        }
        {
          name: duc_private_policy
          allowed_wr:
          [
            CAT3_DEBUG
            ROT
            PWC
            INT_SOC
            DUC_UC
            MIMT_R_MODE
          ]
          allowed_rd:
          [
            CAT3_DEBUG
            ROT
            PWC
            INT_SOC
            DUC_UC
            MIMT_R_MODE
          ]
          rd_default: 13152
          wr_default: 13152
        }
      ]
      lioGrpP:
      [
        {
          name: all_rd_wr_policy
          allowed_wr:
          [
            NOT_TEE
            M_MODE
            TEE_MODE
            R_CODE
            CAT2_DEBUG
            CAT3_DEBUG
            ROT
            MIO
            PWC
            INT_SOC
            IO_AGENT
            TEE_IO_AGENT
            DUC_UC
            MIMT_R_MODE
          ]
          allowed_rd:
          [
            NOT_TEE
            M_MODE
            TEE_MODE
            R_CODE
            CAT2_DEBUG
            CAT3_DEBUG
            ROT
            MIO
            PWC
            INT_SOC
            IO_AGENT
            TEE_IO_AGENT
            DUC_UC
            MIMT_R_MODE
          ]
          rd_default: 16383
          wr_default: 16383
        }
        {
          name: hw_rot_pwc_wr_all_rd_policy
          allowed_wr:
          [
            CAT3_DEBUG
            ROT
            PWC
            INT_SOC
          ]
          allowed_rd:
          [
            NOT_TEE
            M_MODE
            TEE_MODE
            R_CODE
            CAT2_DEBUG
            CAT3_DEBUG
            ROT
            MIO
            PWC
            INT_SOC
            IO_AGENT
            TEE_IO_AGENT
            DUC_UC
            MIMT_R_MODE
          ]
          rd_default: 16383
          wr_default: 864
        }
        {
          name: pre_boot_m_policy
          allowed_wr:
          [
            M_MODE
            R_CODE
            CAT2_DEBUG
            CAT3_DEBUG
            ROT
            PWC
            INT_SOC
          ]
          allowed_rd:
          [
            NOT_TEE
            M_MODE
            TEE_MODE
            R_CODE
            CAT2_DEBUG
            CAT3_DEBUG
            ROT
            MIO
            PWC
            INT_SOC
          ]
          rd_default: 1023
          wr_default: 890
        }
        {
          name: post_boot_m_policy
          allowed_wr:
          [
            M_MODE
            R_CODE
            CAT2_DEBUG
            CAT3_DEBUG
            ROT
            PWC
            INT_SOC
          ]
          allowed_rd:
          [
            NOT_TEE
            M_MODE
            TEE_MODE
            R_CODE
            CAT2_DEBUG
            CAT3_DEBUG
            ROT
            MIO
            PWC
            INT_SOC
          ]
          rd_default: 1023
          wr_default: 890
        }
        {
          name: tee_limited_policy
          allowed_wr:
          [
            TEE_MODE
            R_CODE
            CAT2_DEBUG
            CAT3_DEBUG
            ROT
            PWC
            INT_SOC
            TEE_IO_AGENT
          ]
          allowed_rd:
          [
            TEE_MODE
            R_CODE
            CAT2_DEBUG
            CAT3_DEBUG
            ROT
            PWC
            INT_SOC
            TEE_IO_AGENT
          ]
          rd_default: 2940
          wr_default: 2940
        }
        {
          name: rcode_private_policy
          allowed_wr:
          [
            R_CODE
            CAT3_DEBUG
            ROT
            PWC
            INT_SOC
          ]
          allowed_rd:
          [
            R_CODE
            CAT3_DEBUG
            ROT
            PWC
            INT_SOC
          ]
          rd_default: 872
          wr_default: 872
        }
        {
          name: rot_private_policy
          allowed_wr:
          [
            CAT3_DEBUG
            ROT
          ]
          allowed_rd:
          [
            CAT3_DEBUG
            ROT
          ]
          rd_default: 96
          wr_default: 96
        }
        {
          name: pwc_private_policy
          allowed_wr:
          [
            CAT3_DEBUG
            ROT
            PWC
            INT_SOC
          ]
          allowed_rd:
          [
            CAT3_DEBUG
            ROT
            PWC
            INT_SOC
          ]
          rd_default: 864
          wr_default: 864
        }
        {
          name: mio_private_policy
          allowed_wr:
          [
            CAT3_DEBUG
            ROT
            MIO
            PWC
            INT_SOC
          ]
          allowed_rd:
          [
            CAT3_DEBUG
            ROT
            MIO
            PWC
            INT_SOC
          ]
          rd_default: 992
          wr_default: 992
        }
        {
          name: duc_private_policy
          allowed_wr:
          [
            CAT3_DEBUG
            ROT
            PWC
            INT_SOC
            DUC_UC
            MIMT_R_MODE
          ]
          allowed_rd:
          [
            CAT3_DEBUG
            ROT
            PWC
            INT_SOC
            DUC_UC
            MIMT_R_MODE
          ]
          rd_default: 13152
          wr_default: 13152
        }
      ]
      scsifregshdr:
      [
        {
          name: all_rd_wr_policy
          allowed_wr:
          [
            NOT_TEE
            M_MODE
            TEE_MODE
            R_CODE
            CAT2_DEBUG
            CAT3_DEBUG
            ROT
            MIO
            PWC
            INT_SOC
            IO_AGENT
            TEE_IO_AGENT
            DUC_UC
            MIMT_R_MODE
          ]
          allowed_rd:
          [
            NOT_TEE
            M_MODE
            TEE_MODE
            R_CODE
            CAT2_DEBUG
            CAT3_DEBUG
            ROT
            MIO
            PWC
            INT_SOC
            IO_AGENT
            TEE_IO_AGENT
            DUC_UC
            MIMT_R_MODE
          ]
          rd_default: 16383
          wr_default: 16383
        }
        {
          name: hw_rot_pwc_wr_all_rd_policy
          allowed_wr:
          [
            CAT3_DEBUG
            ROT
            PWC
            INT_SOC
          ]
          allowed_rd:
          [
            NOT_TEE
            M_MODE
            TEE_MODE
            R_CODE
            CAT2_DEBUG
            CAT3_DEBUG
            ROT
            MIO
            PWC
            INT_SOC
            IO_AGENT
            TEE_IO_AGENT
            DUC_UC
            MIMT_R_MODE
          ]
          rd_default: 16383
          wr_default: 864
        }
        {
          name: pre_boot_m_policy
          allowed_wr:
          [
            M_MODE
            R_CODE
            CAT2_DEBUG
            CAT3_DEBUG
            ROT
            PWC
            INT_SOC
          ]
          allowed_rd:
          [
            NOT_TEE
            M_MODE
            TEE_MODE
            R_CODE
            CAT2_DEBUG
            CAT3_DEBUG
            ROT
            MIO
            PWC
            INT_SOC
          ]
          rd_default: 1023
          wr_default: 890
        }
        {
          name: post_boot_m_policy
          allowed_wr:
          [
            M_MODE
            R_CODE
            CAT2_DEBUG
            CAT3_DEBUG
            ROT
            PWC
            INT_SOC
          ]
          allowed_rd:
          [
            NOT_TEE
            M_MODE
            TEE_MODE
            R_CODE
            CAT2_DEBUG
            CAT3_DEBUG
            ROT
            MIO
            PWC
            INT_SOC
          ]
          rd_default: 1023
          wr_default: 890
        }
        {
          name: tee_limited_policy
          allowed_wr:
          [
            TEE_MODE
            R_CODE
            CAT2_DEBUG
            CAT3_DEBUG
            ROT
            PWC
            INT_SOC
            TEE_IO_AGENT
          ]
          allowed_rd:
          [
            TEE_MODE
            R_CODE
            CAT2_DEBUG
            CAT3_DEBUG
            ROT
            PWC
            INT_SOC
            TEE_IO_AGENT
          ]
          rd_default: 2940
          wr_default: 2940
        }
        {
          name: rcode_private_policy
          allowed_wr:
          [
            R_CODE
            CAT3_DEBUG
            ROT
            PWC
            INT_SOC
          ]
          allowed_rd:
          [
            R_CODE
            CAT3_DEBUG
            ROT
            PWC
            INT_SOC
          ]
          rd_default: 872
          wr_default: 872
        }
        {
          name: rot_private_policy
          allowed_wr:
          [
            CAT3_DEBUG
            ROT
          ]
          allowed_rd:
          [
            CAT3_DEBUG
            ROT
          ]
          rd_default: 96
          wr_default: 96
        }
        {
          name: pwc_private_policy
          allowed_wr:
          [
            CAT3_DEBUG
            ROT
            PWC
            INT_SOC
          ]
          allowed_rd:
          [
            CAT3_DEBUG
            ROT
            PWC
            INT_SOC
          ]
          rd_default: 864
          wr_default: 864
        }
        {
          name: mio_private_policy
          allowed_wr:
          [
            CAT3_DEBUG
            ROT
            MIO
            PWC
            INT_SOC
          ]
          allowed_rd:
          [
            CAT3_DEBUG
            ROT
            MIO
            PWC
            INT_SOC
          ]
          rd_default: 992
          wr_default: 992
        }
        {
          name: duc_private_policy
          allowed_wr:
          [
            CAT3_DEBUG
            ROT
            PWC
            INT_SOC
            DUC_UC
            MIMT_R_MODE
          ]
          allowed_rd:
          [
            CAT3_DEBUG
            ROT
            PWC
            INT_SOC
            DUC_UC
            MIMT_R_MODE
          ]
          rd_default: 13152
          wr_default: 13152
        }
      ]
      lioGrpA:
      [
        {
          name: all_rd_wr_policy
          allowed_wr:
          [
            NOT_TEE
            M_MODE
            TEE_MODE
            R_CODE
            CAT2_DEBUG
            CAT3_DEBUG
            ROT
            MIO
            PWC
            INT_SOC
            IO_AGENT
            TEE_IO_AGENT
            DUC_UC
            MIMT_R_MODE
          ]
          allowed_rd:
          [
            NOT_TEE
            M_MODE
            TEE_MODE
            R_CODE
            CAT2_DEBUG
            CAT3_DEBUG
            ROT
            MIO
            PWC
            INT_SOC
            IO_AGENT
            TEE_IO_AGENT
            DUC_UC
            MIMT_R_MODE
          ]
          rd_default: 16383
          wr_default: 16383
        }
        {
          name: rot_private_policy
          allowed_wr:
          [
            CAT3_DEBUG
            ROT
          ]
          allowed_rd:
          [
            CAT3_DEBUG
            ROT
          ]
          rd_default: 96
          wr_default: 96
        }
        {
          name: hw_rot_pwc_wr_all_rd_policy
          allowed_wr:
          [
            CAT3_DEBUG
            ROT
            PWC
            INT_SOC
          ]
          allowed_rd:
          [
            NOT_TEE
            M_MODE
            TEE_MODE
            R_CODE
            CAT2_DEBUG
            CAT3_DEBUG
            ROT
            MIO
            PWC
            INT_SOC
            IO_AGENT
            TEE_IO_AGENT
            DUC_UC
            MIMT_R_MODE
          ]
          rd_default: 16383
          wr_default: 864
        }
        {
          name: pwc_private_policy
          allowed_wr:
          [
            CAT3_DEBUG
            ROT
            PWC
            INT_SOC
          ]
          allowed_rd:
          [
            CAT3_DEBUG
            ROT
            PWC
            INT_SOC
          ]
          rd_default: 864
          wr_default: 864
        }
        {
          name: mio_private_policy
          allowed_wr:
          [
            CAT3_DEBUG
            ROT
            MIO
            PWC
            INT_SOC
          ]
          allowed_rd:
          [
            CAT3_DEBUG
            ROT
            MIO
            PWC
            INT_SOC
          ]
          rd_default: 992
          wr_default: 992
        }
        {
          name: pwmPolicy
          allowed_wr:
          [
            CAT3_DEBUG
            ROT
          ]
          allowed_rd:
          [
            CAT3_DEBUG
            ROT
          ]
          rd_default: 96
          wr_default: 96
        }
        {
          name: gpioPolicy
          allowed_wr:
          [
            CAT3_DEBUG
            ROT
          ]
          allowed_rd:
          [
            CAT3_DEBUG
            ROT
          ]
          rd_default: 96
          wr_default: 96
        }
        {
          name: uartPolicy
          allowed_wr:
          [
            CAT3_DEBUG
            ROT
          ]
          allowed_rd:
          [
            CAT3_DEBUG
            ROT
          ]
          rd_default: 96
          wr_default: 96
        }
        {
          name: i2c0Policy
          allowed_wr:
          [
            CAT3_DEBUG
            ROT
          ]
          allowed_rd:
          [
            CAT3_DEBUG
            ROT
          ]
          rd_default: 96
          wr_default: 96
        }
        {
          name: i2c1Policy
          allowed_wr:
          [
            CAT3_DEBUG
            ROT
          ]
          allowed_rd:
          [
            CAT3_DEBUG
            ROT
          ]
          rd_default: 96
          wr_default: 96
        }
        {
          name: i2c2Policy
          allowed_wr:
          [
            CAT3_DEBUG
            ROT
          ]
          allowed_rd:
          [
            CAT3_DEBUG
            ROT
          ]
          rd_default: 96
          wr_default: 96
        }
        {
          name: i3c0Policy
          allowed_wr:
          [
            CAT3_DEBUG
            ROT
          ]
          allowed_rd:
          [
            CAT3_DEBUG
            ROT
          ]
          rd_default: 96
          wr_default: 96
        }
        {
          name: i3c1Policy
          allowed_wr:
          [
            CAT3_DEBUG
            ROT
          ]
          allowed_rd:
          [
            CAT3_DEBUG
            ROT
          ]
          rd_default: 96
          wr_default: 96
        }
        {
          name: i3c2Policy
          allowed_wr:
          [
            CAT3_DEBUG
            ROT
          ]
          allowed_rd:
          [
            CAT3_DEBUG
            ROT
          ]
          rd_default: 96
          wr_default: 96
        }
        {
          name: spihstPolicy
          allowed_wr:
          [
            CAT3_DEBUG
            ROT
          ]
          allowed_rd:
          [
            CAT3_DEBUG
            ROT
          ]
          rd_default: 96
          wr_default: 96
        }
        {
          name: spidevPolicy
          allowed_wr:
          [
            CAT3_DEBUG
            ROT
          ]
          allowed_rd:
          [
            CAT3_DEBUG
            ROT
          ]
          rd_default: 96
          wr_default: 96
        }
        {
          name: plicPolicy
          allowed_wr:
          [
            CAT3_DEBUG
            ROT
          ]
          allowed_rd:
          [
            CAT3_DEBUG
            ROT
          ]
          rd_default: 96
          wr_default: 96
        }
        {
          name: timerPolicy
          allowed_wr:
          [
            CAT3_DEBUG
            ROT
          ]
          allowed_rd:
          [
            CAT3_DEBUG
            ROT
          ]
          rd_default: 96
          wr_default: 96
        }
      ]
      lioGrpB:
      [
        {
          name: all_rd_wr_policy
          allowed_wr:
          [
            NOT_TEE
            M_MODE
            TEE_MODE
            R_CODE
            CAT2_DEBUG
            CAT3_DEBUG
            ROT
            MIO
            PWC
            INT_SOC
            IO_AGENT
            TEE_IO_AGENT
            DUC_UC
            MIMT_R_MODE
          ]
          allowed_rd:
          [
            NOT_TEE
            M_MODE
            TEE_MODE
            R_CODE
            CAT2_DEBUG
            CAT3_DEBUG
            ROT
            MIO
            PWC
            INT_SOC
            IO_AGENT
            TEE_IO_AGENT
            DUC_UC
            MIMT_R_MODE
          ]
          rd_default: 16383
          wr_default: 16383
        }
        {
          name: rot_private_policy
          allowed_wr:
          [
            CAT3_DEBUG
            ROT
          ]
          allowed_rd:
          [
            CAT3_DEBUG
            ROT
          ]
          rd_default: 96
          wr_default: 96
        }
        {
          name: hw_rot_pwc_wr_all_rd_policy
          allowed_wr:
          [
            CAT3_DEBUG
            ROT
            PWC
            INT_SOC
          ]
          allowed_rd:
          [
            NOT_TEE
            M_MODE
            TEE_MODE
            R_CODE
            CAT2_DEBUG
            CAT3_DEBUG
            ROT
            MIO
            PWC
            INT_SOC
            IO_AGENT
            TEE_IO_AGENT
            DUC_UC
            MIMT_R_MODE
          ]
          rd_default: 16383
          wr_default: 864
        }
        {
          name: pwc_private_policy
          allowed_wr:
          [
            CAT3_DEBUG
            ROT
            PWC
            INT_SOC
          ]
          allowed_rd:
          [
            CAT3_DEBUG
            ROT
            PWC
            INT_SOC
          ]
          rd_default: 864
          wr_default: 864
        }
        {
          name: mio_private_policy
          allowed_wr:
          [
            CAT3_DEBUG
            ROT
            MIO
            PWC
            INT_SOC
          ]
          allowed_rd:
          [
            CAT3_DEBUG
            ROT
            MIO
            PWC
            INT_SOC
          ]
          rd_default: 992
          wr_default: 992
        }
        {
          name: pwmPolicy
          allowed_wr:
          [
            CAT3_DEBUG
            ROT
            PWC
            INT_SOC
          ]
          allowed_rd:
          [
            CAT3_DEBUG
            ROT
            PWC
            INT_SOC
          ]
          rd_default: 864
          wr_default: 864
        }
        {
          name: gpioPolicy
          allowed_wr:
          [
            CAT3_DEBUG
            ROT
            PWC
            INT_SOC
          ]
          allowed_rd:
          [
            CAT3_DEBUG
            ROT
            PWC
            INT_SOC
          ]
          rd_default: 864
          wr_default: 864
        }
        {
          name: uartPolicy
          allowed_wr:
          [
            CAT3_DEBUG
            ROT
            PWC
            INT_SOC
          ]
          allowed_rd:
          [
            CAT3_DEBUG
            ROT
            PWC
            INT_SOC
          ]
          rd_default: 864
          wr_default: 864
        }
        {
          name: i2c0Policy
          allowed_wr:
          [
            CAT3_DEBUG
            ROT
            PWC
            INT_SOC
          ]
          allowed_rd:
          [
            CAT3_DEBUG
            ROT
            PWC
            INT_SOC
          ]
          rd_default: 864
          wr_default: 864
        }
        {
          name: i2c1Policy
          allowed_wr:
          [
            CAT3_DEBUG
            ROT
            PWC
            INT_SOC
          ]
          allowed_rd:
          [
            CAT3_DEBUG
            ROT
            PWC
            INT_SOC
          ]
          rd_default: 864
          wr_default: 864
        }
        {
          name: i2c2Policy
          allowed_wr:
          [
            CAT3_DEBUG
            ROT
            PWC
            INT_SOC
          ]
          allowed_rd:
          [
            CAT3_DEBUG
            ROT
            PWC
            INT_SOC
          ]
          rd_default: 864
          wr_default: 864
        }
        {
          name: i3c0Policy
          allowed_wr:
          [
            CAT3_DEBUG
            ROT
            PWC
            INT_SOC
          ]
          allowed_rd:
          [
            CAT3_DEBUG
            ROT
            PWC
            INT_SOC
          ]
          rd_default: 864
          wr_default: 864
        }
        {
          name: i3c1Policy
          allowed_wr:
          [
            CAT3_DEBUG
            ROT
            PWC
            INT_SOC
          ]
          allowed_rd:
          [
            CAT3_DEBUG
            ROT
            PWC
            INT_SOC
          ]
          rd_default: 864
          wr_default: 864
        }
        {
          name: i3c2Policy
          allowed_wr:
          [
            CAT3_DEBUG
            ROT
            PWC
            INT_SOC
          ]
          allowed_rd:
          [
            CAT3_DEBUG
            ROT
            PWC
            INT_SOC
          ]
          rd_default: 864
          wr_default: 864
        }
        {
          name: spihstPolicy
          allowed_wr:
          [
            CAT3_DEBUG
            ROT
            PWC
            INT_SOC
          ]
          allowed_rd:
          [
            CAT3_DEBUG
            ROT
            PWC
            INT_SOC
          ]
          rd_default: 864
          wr_default: 864
        }
        {
          name: spidevPolicy
          allowed_wr:
          [
            CAT3_DEBUG
            ROT
            PWC
            INT_SOC
          ]
          allowed_rd:
          [
            CAT3_DEBUG
            ROT
            PWC
            INT_SOC
          ]
          rd_default: 864
          wr_default: 864
        }
        {
          name: plicPolicy
          allowed_wr:
          [
            CAT3_DEBUG
            ROT
            PWC
            INT_SOC
          ]
          allowed_rd:
          [
            CAT3_DEBUG
            ROT
            PWC
            INT_SOC
          ]
          rd_default: 864
          wr_default: 864
        }
        {
          name: timerPolicy
          allowed_wr:
          [
            CAT3_DEBUG
            ROT
            PWC
            INT_SOC
          ]
          allowed_rd:
          [
            CAT3_DEBUG
            ROT
            PWC
            INT_SOC
          ]
          rd_default: 864
          wr_default: 864
        }
      ]
      lioGrpC:
      [
        {
          name: all_rd_wr_policy
          allowed_wr:
          [
            NOT_TEE
            M_MODE
            TEE_MODE
            R_CODE
            CAT2_DEBUG
            CAT3_DEBUG
            ROT
            MIO
            PWC
            INT_SOC
            IO_AGENT
            TEE_IO_AGENT
            DUC_UC
            MIMT_R_MODE
          ]
          allowed_rd:
          [
            NOT_TEE
            M_MODE
            TEE_MODE
            R_CODE
            CAT2_DEBUG
            CAT3_DEBUG
            ROT
            MIO
            PWC
            INT_SOC
            IO_AGENT
            TEE_IO_AGENT
            DUC_UC
            MIMT_R_MODE
          ]
          rd_default: 16383
          wr_default: 16383
        }
        {
          name: rot_private_policy
          allowed_wr:
          [
            CAT3_DEBUG
            ROT
          ]
          allowed_rd:
          [
            CAT3_DEBUG
            ROT
          ]
          rd_default: 96
          wr_default: 96
        }
        {
          name: hw_rot_pwc_wr_all_rd_policy
          allowed_wr:
          [
            CAT3_DEBUG
            ROT
            PWC
            INT_SOC
          ]
          allowed_rd:
          [
            NOT_TEE
            M_MODE
            TEE_MODE
            R_CODE
            CAT2_DEBUG
            CAT3_DEBUG
            ROT
            MIO
            PWC
            INT_SOC
            IO_AGENT
            TEE_IO_AGENT
            DUC_UC
            MIMT_R_MODE
          ]
          rd_default: 16383
          wr_default: 864
        }
        {
          name: pwc_private_policy
          allowed_wr:
          [
            CAT3_DEBUG
            ROT
            PWC
            INT_SOC
          ]
          allowed_rd:
          [
            CAT3_DEBUG
            ROT
            PWC
            INT_SOC
          ]
          rd_default: 864
          wr_default: 864
        }
        {
          name: mio_private_policy
          allowed_wr:
          [
            CAT3_DEBUG
            ROT
            MIO
            PWC
            INT_SOC
          ]
          allowed_rd:
          [
            CAT3_DEBUG
            ROT
            MIO
            PWC
            INT_SOC
          ]
          rd_default: 992
          wr_default: 992
        }
        {
          name: pwmPolicy
          allowed_wr:
          [
            CAT3_DEBUG
            ROT
            MIO
            PWC
            INT_SOC
          ]
          allowed_rd:
          [
            CAT3_DEBUG
            ROT
            MIO
            PWC
            INT_SOC
          ]
          rd_default: 992
          wr_default: 992
        }
        {
          name: gpioPolicy
          allowed_wr:
          [
            CAT3_DEBUG
            ROT
            MIO
            PWC
            INT_SOC
          ]
          allowed_rd:
          [
            CAT3_DEBUG
            ROT
            MIO
            PWC
            INT_SOC
          ]
          rd_default: 992
          wr_default: 992
        }
        {
          name: uartPolicy
          allowed_wr:
          [
            CAT3_DEBUG
            ROT
            MIO
            PWC
            INT_SOC
          ]
          allowed_rd:
          [
            CAT3_DEBUG
            ROT
            MIO
            PWC
            INT_SOC
          ]
          rd_default: 992
          wr_default: 992
        }
        {
          name: i2c0Policy
          allowed_wr:
          [
            CAT3_DEBUG
            ROT
            MIO
            PWC
            INT_SOC
          ]
          allowed_rd:
          [
            CAT3_DEBUG
            ROT
            MIO
            PWC
            INT_SOC
          ]
          rd_default: 992
          wr_default: 992
        }
        {
          name: i2c1Policy
          allowed_wr:
          [
            CAT3_DEBUG
            ROT
            MIO
            PWC
            INT_SOC
          ]
          allowed_rd:
          [
            CAT3_DEBUG
            ROT
            MIO
            PWC
            INT_SOC
          ]
          rd_default: 992
          wr_default: 992
        }
        {
          name: i2c2Policy
          allowed_wr:
          [
            CAT3_DEBUG
            ROT
            MIO
            PWC
            INT_SOC
          ]
          allowed_rd:
          [
            CAT3_DEBUG
            ROT
            MIO
            PWC
            INT_SOC
          ]
          rd_default: 992
          wr_default: 992
        }
        {
          name: i3c0Policy
          allowed_wr:
          [
            CAT3_DEBUG
            ROT
            MIO
            PWC
            INT_SOC
          ]
          allowed_rd:
          [
            CAT3_DEBUG
            ROT
            MIO
            PWC
            INT_SOC
          ]
          rd_default: 992
          wr_default: 992
        }
        {
          name: i3c1Policy
          allowed_wr:
          [
            CAT3_DEBUG
            ROT
            MIO
            PWC
            INT_SOC
          ]
          allowed_rd:
          [
            CAT3_DEBUG
            ROT
            MIO
            PWC
            INT_SOC
          ]
          rd_default: 992
          wr_default: 992
        }
        {
          name: i3c2Policy
          allowed_wr:
          [
            CAT3_DEBUG
            ROT
            MIO
            PWC
            INT_SOC
          ]
          allowed_rd:
          [
            CAT3_DEBUG
            ROT
            MIO
            PWC
            INT_SOC
          ]
          rd_default: 992
          wr_default: 992
        }
        {
          name: spihstPolicy
          allowed_wr:
          [
            CAT3_DEBUG
            ROT
            MIO
            PWC
            INT_SOC
          ]
          allowed_rd:
          [
            CAT3_DEBUG
            ROT
            MIO
            PWC
            INT_SOC
          ]
          rd_default: 992
          wr_default: 992
        }
        {
          name: spidevPolicy
          allowed_wr:
          [
            CAT3_DEBUG
            ROT
            MIO
            PWC
            INT_SOC
          ]
          allowed_rd:
          [
            CAT3_DEBUG
            ROT
            MIO
            PWC
            INT_SOC
          ]
          rd_default: 992
          wr_default: 992
        }
        {
          name: plicPolicy
          allowed_wr:
          [
            CAT3_DEBUG
            ROT
            MIO
            PWC
            INT_SOC
          ]
          allowed_rd:
          [
            CAT3_DEBUG
            ROT
            MIO
            PWC
            INT_SOC
          ]
          rd_default: 992
          wr_default: 992
        }
        {
          name: timerPolicy
          allowed_wr:
          [
            CAT3_DEBUG
            ROT
            MIO
            PWC
            INT_SOC
          ]
          allowed_rd:
          [
            CAT3_DEBUG
            ROT
            MIO
            PWC
            INT_SOC
          ]
          rd_default: 992
          wr_default: 992
        }
      ]
      lioGrpD:
      [
        {
          name: all_rd_wr_policy
          allowed_wr:
          [
            NOT_TEE
            M_MODE
            TEE_MODE
            R_CODE
            CAT2_DEBUG
            CAT3_DEBUG
            ROT
            MIO
            PWC
            INT_SOC
            IO_AGENT
            TEE_IO_AGENT
            DUC_UC
            MIMT_R_MODE
          ]
          allowed_rd:
          [
            NOT_TEE
            M_MODE
            TEE_MODE
            R_CODE
            CAT2_DEBUG
            CAT3_DEBUG
            ROT
            MIO
            PWC
            INT_SOC
            IO_AGENT
            TEE_IO_AGENT
            DUC_UC
            MIMT_R_MODE
          ]
          rd_default: 16383
          wr_default: 16383
        }
        {
          name: rot_private_policy
          allowed_wr:
          [
            CAT3_DEBUG
            ROT
          ]
          allowed_rd:
          [
            CAT3_DEBUG
            ROT
          ]
          rd_default: 96
          wr_default: 96
        }
        {
          name: hw_rot_pwc_wr_all_rd_policy
          allowed_wr:
          [
            CAT3_DEBUG
            ROT
            PWC
            INT_SOC
          ]
          allowed_rd:
          [
            NOT_TEE
            M_MODE
            TEE_MODE
            R_CODE
            CAT2_DEBUG
            CAT3_DEBUG
            ROT
            MIO
            PWC
            INT_SOC
            IO_AGENT
            TEE_IO_AGENT
            DUC_UC
            MIMT_R_MODE
          ]
          rd_default: 16383
          wr_default: 864
        }
        {
          name: pwc_private_policy
          allowed_wr:
          [
            CAT3_DEBUG
            ROT
            PWC
            INT_SOC
          ]
          allowed_rd:
          [
            CAT3_DEBUG
            ROT
            PWC
            INT_SOC
          ]
          rd_default: 864
          wr_default: 864
        }
        {
          name: mio_private_policy
          allowed_wr:
          [
            CAT3_DEBUG
            ROT
            MIO
            PWC
            INT_SOC
          ]
          allowed_rd:
          [
            CAT3_DEBUG
            ROT
            MIO
            PWC
            INT_SOC
          ]
          rd_default: 992
          wr_default: 992
        }
        {
          name: pwmPolicy
          allowed_wr:
          [
            NOT_TEE
            M_MODE
            TEE_MODE
            R_CODE
            CAT2_DEBUG
            CAT3_DEBUG
            ROT
            MIO
            PWC
            INT_SOC
            IO_AGENT
            TEE_IO_AGENT
            DUC_UC
            MIMT_R_MODE
          ]
          allowed_rd:
          [
            NOT_TEE
            M_MODE
            TEE_MODE
            R_CODE
            CAT2_DEBUG
            CAT3_DEBUG
            ROT
            MIO
            PWC
            INT_SOC
            IO_AGENT
            TEE_IO_AGENT
            DUC_UC
            MIMT_R_MODE
          ]
          rd_default: 16383
          wr_default: 16383
        }
        {
          name: gpioPolicy
          allowed_wr:
          [
            NOT_TEE
            M_MODE
            TEE_MODE
            R_CODE
            CAT2_DEBUG
            CAT3_DEBUG
            ROT
            MIO
            PWC
            INT_SOC
            IO_AGENT
            TEE_IO_AGENT
            DUC_UC
            MIMT_R_MODE
          ]
          allowed_rd:
          [
            NOT_TEE
            M_MODE
            TEE_MODE
            R_CODE
            CAT2_DEBUG
            CAT3_DEBUG
            ROT
            MIO
            PWC
            INT_SOC
            IO_AGENT
            TEE_IO_AGENT
            DUC_UC
            MIMT_R_MODE
          ]
          rd_default: 16383
          wr_default: 16383
        }
        {
          name: uartPolicy
          allowed_wr:
          [
            NOT_TEE
            M_MODE
            TEE_MODE
            R_CODE
            CAT2_DEBUG
            CAT3_DEBUG
            ROT
            MIO
            PWC
            INT_SOC
            IO_AGENT
            TEE_IO_AGENT
            DUC_UC
            MIMT_R_MODE
          ]
          allowed_rd:
          [
            NOT_TEE
            M_MODE
            TEE_MODE
            R_CODE
            CAT2_DEBUG
            CAT3_DEBUG
            ROT
            MIO
            PWC
            INT_SOC
            IO_AGENT
            TEE_IO_AGENT
            DUC_UC
            MIMT_R_MODE
          ]
          rd_default: 16383
          wr_default: 16383
        }
        {
          name: i2c0Policy
          allowed_wr:
          [
            NOT_TEE
            M_MODE
            TEE_MODE
            R_CODE
            CAT2_DEBUG
            CAT3_DEBUG
            ROT
            MIO
            PWC
            INT_SOC
            IO_AGENT
            TEE_IO_AGENT
            DUC_UC
            MIMT_R_MODE
          ]
          allowed_rd:
          [
            NOT_TEE
            M_MODE
            TEE_MODE
            R_CODE
            CAT2_DEBUG
            CAT3_DEBUG
            ROT
            MIO
            PWC
            INT_SOC
            IO_AGENT
            TEE_IO_AGENT
            DUC_UC
            MIMT_R_MODE
          ]
          rd_default: 16383
          wr_default: 16383
        }
        {
          name: i2c1Policy
          allowed_wr:
          [
            NOT_TEE
            M_MODE
            TEE_MODE
            R_CODE
            CAT2_DEBUG
            CAT3_DEBUG
            ROT
            MIO
            PWC
            INT_SOC
            IO_AGENT
            TEE_IO_AGENT
            DUC_UC
            MIMT_R_MODE
          ]
          allowed_rd:
          [
            NOT_TEE
            M_MODE
            TEE_MODE
            R_CODE
            CAT2_DEBUG
            CAT3_DEBUG
            ROT
            MIO
            PWC
            INT_SOC
            IO_AGENT
            TEE_IO_AGENT
            DUC_UC
            MIMT_R_MODE
          ]
          rd_default: 16383
          wr_default: 16383
        }
        {
          name: i2c2Policy
          allowed_wr:
          [
            NOT_TEE
            M_MODE
            TEE_MODE
            R_CODE
            CAT2_DEBUG
            CAT3_DEBUG
            ROT
            MIO
            PWC
            INT_SOC
            IO_AGENT
            TEE_IO_AGENT
            DUC_UC
            MIMT_R_MODE
          ]
          allowed_rd:
          [
            NOT_TEE
            M_MODE
            TEE_MODE
            R_CODE
            CAT2_DEBUG
            CAT3_DEBUG
            ROT
            MIO
            PWC
            INT_SOC
            IO_AGENT
            TEE_IO_AGENT
            DUC_UC
            MIMT_R_MODE
          ]
          rd_default: 16383
          wr_default: 16383
        }
        {
          name: i3c0Policy
          allowed_wr:
          [
            NOT_TEE
            M_MODE
            TEE_MODE
            R_CODE
            CAT2_DEBUG
            CAT3_DEBUG
            ROT
            MIO
            PWC
            INT_SOC
            IO_AGENT
            TEE_IO_AGENT
            DUC_UC
            MIMT_R_MODE
          ]
          allowed_rd:
          [
            NOT_TEE
            M_MODE
            TEE_MODE
            R_CODE
            CAT2_DEBUG
            CAT3_DEBUG
            ROT
            MIO
            PWC
            INT_SOC
            IO_AGENT
            TEE_IO_AGENT
            DUC_UC
            MIMT_R_MODE
          ]
          rd_default: 16383
          wr_default: 16383
        }
        {
          name: i3c1Policy
          allowed_wr:
          [
            NOT_TEE
            M_MODE
            TEE_MODE
            R_CODE
            CAT2_DEBUG
            CAT3_DEBUG
            ROT
            MIO
            PWC
            INT_SOC
            IO_AGENT
            TEE_IO_AGENT
            DUC_UC
            MIMT_R_MODE
          ]
          allowed_rd:
          [
            NOT_TEE
            M_MODE
            TEE_MODE
            R_CODE
            CAT2_DEBUG
            CAT3_DEBUG
            ROT
            MIO
            PWC
            INT_SOC
            IO_AGENT
            TEE_IO_AGENT
            DUC_UC
            MIMT_R_MODE
          ]
          rd_default: 16383
          wr_default: 16383
        }
        {
          name: i3c2Policy
          allowed_wr:
          [
            NOT_TEE
            M_MODE
            TEE_MODE
            R_CODE
            CAT2_DEBUG
            CAT3_DEBUG
            ROT
            MIO
            PWC
            INT_SOC
            IO_AGENT
            TEE_IO_AGENT
            DUC_UC
            MIMT_R_MODE
          ]
          allowed_rd:
          [
            NOT_TEE
            M_MODE
            TEE_MODE
            R_CODE
            CAT2_DEBUG
            CAT3_DEBUG
            ROT
            MIO
            PWC
            INT_SOC
            IO_AGENT
            TEE_IO_AGENT
            DUC_UC
            MIMT_R_MODE
          ]
          rd_default: 16383
          wr_default: 16383
        }
        {
          name: spihstPolicy
          allowed_wr:
          [
            NOT_TEE
            M_MODE
            TEE_MODE
            R_CODE
            CAT2_DEBUG
            CAT3_DEBUG
            ROT
            MIO
            PWC
            INT_SOC
            IO_AGENT
            TEE_IO_AGENT
            DUC_UC
            MIMT_R_MODE
          ]
          allowed_rd:
          [
            NOT_TEE
            M_MODE
            TEE_MODE
            R_CODE
            CAT2_DEBUG
            CAT3_DEBUG
            ROT
            MIO
            PWC
            INT_SOC
            IO_AGENT
            TEE_IO_AGENT
            DUC_UC
            MIMT_R_MODE
          ]
          rd_default: 16383
          wr_default: 16383
        }
        {
          name: spidevPolicy
          allowed_wr:
          [
            NOT_TEE
            M_MODE
            TEE_MODE
            R_CODE
            CAT2_DEBUG
            CAT3_DEBUG
            ROT
            MIO
            PWC
            INT_SOC
            IO_AGENT
            TEE_IO_AGENT
            DUC_UC
            MIMT_R_MODE
          ]
          allowed_rd:
          [
            NOT_TEE
            M_MODE
            TEE_MODE
            R_CODE
            CAT2_DEBUG
            CAT3_DEBUG
            ROT
            MIO
            PWC
            INT_SOC
            IO_AGENT
            TEE_IO_AGENT
            DUC_UC
            MIMT_R_MODE
          ]
          rd_default: 16383
          wr_default: 16383
        }
        {
          name: plicPolicy
          allowed_wr:
          [
            NOT_TEE
            M_MODE
            TEE_MODE
            R_CODE
            CAT2_DEBUG
            CAT3_DEBUG
            ROT
            MIO
            PWC
            INT_SOC
            IO_AGENT
            TEE_IO_AGENT
            DUC_UC
            MIMT_R_MODE
          ]
          allowed_rd:
          [
            NOT_TEE
            M_MODE
            TEE_MODE
            R_CODE
            CAT2_DEBUG
            CAT3_DEBUG
            ROT
            MIO
            PWC
            INT_SOC
            IO_AGENT
            TEE_IO_AGENT
            DUC_UC
            MIMT_R_MODE
          ]
          rd_default: 16383
          wr_default: 16383
        }
        {
          name: timerPolicy
          allowed_wr:
          [
            NOT_TEE
            M_MODE
            TEE_MODE
            R_CODE
            CAT2_DEBUG
            CAT3_DEBUG
            ROT
            MIO
            PWC
            INT_SOC
            IO_AGENT
            TEE_IO_AGENT
            DUC_UC
            MIMT_R_MODE
          ]
          allowed_rd:
          [
            NOT_TEE
            M_MODE
            TEE_MODE
            R_CODE
            CAT2_DEBUG
            CAT3_DEBUG
            ROT
            MIO
            PWC
            INT_SOC
            IO_AGENT
            TEE_IO_AGENT
            DUC_UC
            MIMT_R_MODE
          ]
          rd_default: 16383
          wr_default: 16383
        }
      ]
    }
    nr_role_bits: 4
    nr_ctn_uid_bits: 5
    nr_policies: 18
    rot_private_policy_rd: 96
    rot_private_policy_wr: 96
  }
  wakeups:
  [
    {
      name: wkup_req
      width: "1"
      module: aon_timer_aon
    }
  ]
  reset_requests:
  {
    peripheral:
    [
      {
        name: aon_timer_rst_req
        width: "1"
        module: aon_timer_aon
        desc: Watchdog reset request.
      }
    ]
  }
  exported_rsts: {}
  alert: []
  outgoing_alert:
  {
    mio:
    [
      {
        name: rv_timer_fatal_fault
        width: 1
        type: alert
        async: "1"
        handler: null
        module_name: rv_timer
        desc: rv_timer fatal_fault alert
        lpg_name: clk_ext_io_div4_i_ext_rst_io_div4_0
        lpg_idx: 0
      }
      {
        name: aon_timer_aon_fatal_fault
        width: 1
        type: alert
        async: "1"
        handler: null
        module_name: aon_timer_aon
        desc: aon_timer_aon fatal_fault alert
        lpg_name: clk_ext_io_div4_i_ext_rst_io_div4_0
        lpg_idx: 0
      }
      {
        name: sram_ctrl_ret_aon_fatal_error
        width: 1
        type: alert
        async: "1"
        handler: null
        module_name: sram_ctrl_ret_aon
        desc: sram_ctrl_ret_aon fatal_error alert
        lpg_name: clk_ext_io_div4_i_ext_rst_io_div4_0
        lpg_idx: 0
      }
      {
        name: rv_dm_fatal_fault
        width: 1
        type: alert
        async: "1"
        handler: null
        module_name: rv_dm
        desc: rv_dm fatal_fault alert
        lpg_name: clk_ext_main_i_ext_rst_main_0
        lpg_idx: 1
      }
      {
        name: rv_plic_mio_fatal_fault
        width: 1
        type: alert
        async: "1"
        handler: null
        module_name: rv_plic_mio
        desc: rv_plic_mio fatal_fault alert
        lpg_name: clk_ext_main_i_ext_rst_main_0
        lpg_idx: 1
      }
      {
        name: sram_ctrl_main_fatal_error
        width: 1
        type: alert
        async: "1"
        handler: null
        module_name: sram_ctrl_main
        desc: sram_ctrl_main fatal_error alert
        lpg_name: clk_ext_main_i_ext_rst_main_0
        lpg_idx: 1
      }
      {
        name: sram_ctrl_mbox_fatal_error
        width: 1
        type: alert
        async: "1"
        handler: null
        module_name: sram_ctrl_mbox
        desc: sram_ctrl_mbox fatal_error alert
        lpg_name: clk_ext_main_i_ext_rst_main_0
        lpg_idx: 1
      }
      {
        name: dma_fatal_fault
        width: 1
        type: alert
        async: "1"
        handler: null
        module_name: dma
        desc: dma fatal_fault alert
        lpg_name: clk_ext_main_i_ext_rst_main_0
        lpg_idx: 1
      }
      {
        name: mbx0_fatal_fault
        width: 1
        type: alert
        async: "1"
        handler: null
        module_name: mbx0
        desc: mbx0 fatal_fault alert
        lpg_name: clk_ext_main_i_ext_rst_main_0
        lpg_idx: 1
      }
      {
        name: mbx0_recov_fault
        width: 1
        type: alert
        async: "1"
        handler: null
        module_name: mbx0
        desc: mbx0 recov_fault alert
        lpg_name: clk_ext_main_i_ext_rst_main_0
        lpg_idx: 1
      }
      {
        name: mbx1_fatal_fault
        width: 1
        type: alert
        async: "1"
        handler: null
        module_name: mbx1
        desc: mbx1 fatal_fault alert
        lpg_name: clk_ext_main_i_ext_rst_main_0
        lpg_idx: 1
      }
      {
        name: mbx1_recov_fault
        width: 1
        type: alert
        async: "1"
        handler: null
        module_name: mbx1
        desc: mbx1 recov_fault alert
        lpg_name: clk_ext_main_i_ext_rst_main_0
        lpg_idx: 1
      }
      {
        name: mbx2_fatal_fault
        width: 1
        type: alert
        async: "1"
        handler: null
        module_name: mbx2
        desc: mbx2 fatal_fault alert
        lpg_name: clk_ext_main_i_ext_rst_main_0
        lpg_idx: 1
      }
      {
        name: mbx2_recov_fault
        width: 1
        type: alert
        async: "1"
        handler: null
        module_name: mbx2
        desc: mbx2 recov_fault alert
        lpg_name: clk_ext_main_i_ext_rst_main_0
        lpg_idx: 1
      }
      {
        name: mbx3_fatal_fault
        width: 1
        type: alert
        async: "1"
        handler: null
        module_name: mbx3
        desc: mbx3 fatal_fault alert
        lpg_name: clk_ext_main_i_ext_rst_main_0
        lpg_idx: 1
      }
      {
        name: mbx3_recov_fault
        width: 1
        type: alert
        async: "1"
        handler: null
        module_name: mbx3
        desc: mbx3 recov_fault alert
        lpg_name: clk_ext_main_i_ext_rst_main_0
        lpg_idx: 1
      }
      {
        name: mbx4_fatal_fault
        width: 1
        type: alert
        async: "1"
        handler: null
        module_name: mbx4
        desc: mbx4 fatal_fault alert
        lpg_name: clk_ext_main_i_ext_rst_main_0
        lpg_idx: 1
      }
      {
        name: mbx4_recov_fault
        width: 1
        type: alert
        async: "1"
        handler: null
        module_name: mbx4
        desc: mbx4 recov_fault alert
        lpg_name: clk_ext_main_i_ext_rst_main_0
        lpg_idx: 1
      }
      {
        name: mbx5_fatal_fault
        width: 1
        type: alert
        async: "1"
        handler: null
        module_name: mbx5
        desc: mbx5 fatal_fault alert
        lpg_name: clk_ext_main_i_ext_rst_main_0
        lpg_idx: 1
      }
      {
        name: mbx5_recov_fault
        width: 1
        type: alert
        async: "1"
        handler: null
        module_name: mbx5
        desc: mbx5 recov_fault alert
        lpg_name: clk_ext_main_i_ext_rst_main_0
        lpg_idx: 1
      }
      {
        name: mbx_pcie0_fatal_fault
        width: 1
        type: alert
        async: "1"
        handler: null
        module_name: mbx_pcie0
        desc: mbx_pcie0 fatal_fault alert
        lpg_name: clk_ext_main_i_ext_rst_main_0
        lpg_idx: 1
      }
      {
        name: mbx_pcie0_recov_fault
        width: 1
        type: alert
        async: "1"
        handler: null
        module_name: mbx_pcie0
        desc: mbx_pcie0 recov_fault alert
        lpg_name: clk_ext_main_i_ext_rst_main_0
        lpg_idx: 1
      }
      {
        name: racl_ctrl_mio_fatal_fault
        width: 1
        type: alert
        async: "1"
        handler: null
        module_name: racl_ctrl_mio
        desc: racl_ctrl_mio fatal_fault alert
        lpg_name: clk_ext_main_i_ext_rst_main_0
        lpg_idx: 1
      }
      {
        name: racl_ctrl_mio_recov_ctrl_update_err
        width: 1
        type: alert
        async: "1"
        handler: null
        module_name: racl_ctrl_mio
        desc: racl_ctrl_mio recov_ctrl_update_err alert
        lpg_name: clk_ext_main_i_ext_rst_main_0
        lpg_idx: 1
      }
      {
        name: ac_range_check_mio_recov_ctrl_update_err
        width: 1
        type: alert
        async: "1"
        handler: null
        module_name: ac_range_check_mio
        desc: ac_range_check_mio recov_ctrl_update_err alert
        lpg_name: clk_ext_main_i_ext_rst_main_0
        lpg_idx: 1
      }
      {
        name: ac_range_check_mio_fatal_fault
        width: 1
        type: alert
        async: "1"
        handler: null
        module_name: ac_range_check_mio
        desc: ac_range_check_mio fatal_fault alert
        lpg_name: clk_ext_main_i_ext_rst_main_0
        lpg_idx: 1
      }
      {
        name: rv_core_ibex_mio_fatal_sw_err
        width: 1
        type: alert
        async: "1"
        handler: null
        module_name: rv_core_ibex_mio
        desc: rv_core_ibex_mio fatal_sw_err alert
        lpg_name: clk_ext_main_i_ext_rst_main_0
        lpg_idx: 1
      }
      {
        name: rv_core_ibex_mio_recov_sw_err
        width: 1
        type: alert
        async: "1"
        handler: null
        module_name: rv_core_ibex_mio
        desc: rv_core_ibex_mio recov_sw_err alert
        lpg_name: clk_ext_main_i_ext_rst_main_0
        lpg_idx: 1
      }
      {
        name: rv_core_ibex_mio_fatal_hw_err
        width: 1
        type: alert
        async: "1"
        handler: null
        module_name: rv_core_ibex_mio
        desc: rv_core_ibex_mio fatal_hw_err alert
        lpg_name: clk_ext_main_i_ext_rst_main_0
        lpg_idx: 1
      }
      {
        name: rv_core_ibex_mio_recov_hw_err
        width: 1
        type: alert
        async: "1"
        handler: null
        module_name: rv_core_ibex_mio
        desc: rv_core_ibex_mio recov_hw_err alert
        lpg_name: clk_ext_main_i_ext_rst_main_0
        lpg_idx: 1
      }
    ]
  }
  interrupt:
  [
    {
      name: rv_timer_timer_expired_hart0_timer0
      width: 1
      type: interrupt
      module_name: rv_timer
      desc: rv_timer timer_expired_hart0_timer0 interrupt
      intr_type: IntrType.Event
      default_val: false
      incoming: false
      plic: rv_plic_mio
      outgoing: false
    }
    {
      name: aon_timer_aon_wkup_timer_expired
      width: 1
      type: interrupt
      module_name: aon_timer_aon
      desc: aon_timer_aon wkup_timer_expired interrupt
      intr_type: IntrType.Event
      default_val: false
      incoming: false
      plic: rv_plic_mio
      outgoing: false
    }
    {
      name: aon_timer_aon_wdog_timer_bark
      width: 1
      type: interrupt
      module_name: aon_timer_aon
      desc: aon_timer_aon wdog_timer_bark interrupt
      intr_type: IntrType.Event
      default_val: false
      incoming: false
      plic: rv_plic_mio
      outgoing: false
    }
    {
      name: dma_dma_done
      width: 1
      type: interrupt
      module_name: dma
      desc: dma dma_done interrupt
      intr_type: IntrType.Status
      default_val: false
      incoming: false
      plic: rv_plic_mio
      outgoing: false
    }
    {
      name: dma_dma_chunk_done
      width: 1
      type: interrupt
      module_name: dma
      desc: dma dma_chunk_done interrupt
      intr_type: IntrType.Status
      default_val: false
      incoming: false
      plic: rv_plic_mio
      outgoing: false
    }
    {
      name: dma_dma_error
      width: 1
      type: interrupt
      module_name: dma
      desc: dma dma_error interrupt
      intr_type: IntrType.Status
      default_val: false
      incoming: false
      plic: rv_plic_mio
      outgoing: false
    }
    {
      name: mbx0_mbx_ready
      width: 1
      type: interrupt
      module_name: mbx0
      desc: mbx0 mbx_ready interrupt
      intr_type: IntrType.Event
      default_val: false
      incoming: false
      plic: rv_plic_mio
      outgoing: false
    }
    {
      name: mbx0_mbx_abort
      width: 1
      type: interrupt
      module_name: mbx0
      desc: mbx0 mbx_abort interrupt
      intr_type: IntrType.Event
      default_val: false
      incoming: false
      plic: rv_plic_mio
      outgoing: false
    }
    {
      name: mbx0_mbx_error
      width: 1
      type: interrupt
      module_name: mbx0
      desc: mbx0 mbx_error interrupt
      intr_type: IntrType.Event
      default_val: false
      incoming: false
      plic: rv_plic_mio
      outgoing: false
    }
    {
      name: mbx1_mbx_ready
      width: 1
      type: interrupt
      module_name: mbx1
      desc: mbx1 mbx_ready interrupt
      intr_type: IntrType.Event
      default_val: false
      incoming: false
      plic: rv_plic_mio
      outgoing: false
    }
    {
      name: mbx1_mbx_abort
      width: 1
      type: interrupt
      module_name: mbx1
      desc: mbx1 mbx_abort interrupt
      intr_type: IntrType.Event
      default_val: false
      incoming: false
      plic: rv_plic_mio
      outgoing: false
    }
    {
      name: mbx1_mbx_error
      width: 1
      type: interrupt
      module_name: mbx1
      desc: mbx1 mbx_error interrupt
      intr_type: IntrType.Event
      default_val: false
      incoming: false
      plic: rv_plic_mio
      outgoing: false
    }
    {
      name: mbx2_mbx_ready
      width: 1
      type: interrupt
      module_name: mbx2
      desc: mbx2 mbx_ready interrupt
      intr_type: IntrType.Event
      default_val: false
      incoming: false
      plic: rv_plic_mio
      outgoing: false
    }
    {
      name: mbx2_mbx_abort
      width: 1
      type: interrupt
      module_name: mbx2
      desc: mbx2 mbx_abort interrupt
      intr_type: IntrType.Event
      default_val: false
      incoming: false
      plic: rv_plic_mio
      outgoing: false
    }
    {
      name: mbx2_mbx_error
      width: 1
      type: interrupt
      module_name: mbx2
      desc: mbx2 mbx_error interrupt
      intr_type: IntrType.Event
      default_val: false
      incoming: false
      plic: rv_plic_mio
      outgoing: false
    }
    {
      name: mbx3_mbx_ready
      width: 1
      type: interrupt
      module_name: mbx3
      desc: mbx3 mbx_ready interrupt
      intr_type: IntrType.Event
      default_val: false
      incoming: false
      plic: rv_plic_mio
      outgoing: false
    }
    {
      name: mbx3_mbx_abort
      width: 1
      type: interrupt
      module_name: mbx3
      desc: mbx3 mbx_abort interrupt
      intr_type: IntrType.Event
      default_val: false
      incoming: false
      plic: rv_plic_mio
      outgoing: false
    }
    {
      name: mbx3_mbx_error
      width: 1
      type: interrupt
      module_name: mbx3
      desc: mbx3 mbx_error interrupt
      intr_type: IntrType.Event
      default_val: false
      incoming: false
      plic: rv_plic_mio
      outgoing: false
    }
    {
      name: mbx4_mbx_ready
      width: 1
      type: interrupt
      module_name: mbx4
      desc: mbx4 mbx_ready interrupt
      intr_type: IntrType.Event
      default_val: false
      incoming: false
      plic: rv_plic_mio
      outgoing: false
    }
    {
      name: mbx4_mbx_abort
      width: 1
      type: interrupt
      module_name: mbx4
      desc: mbx4 mbx_abort interrupt
      intr_type: IntrType.Event
      default_val: false
      incoming: false
      plic: rv_plic_mio
      outgoing: false
    }
    {
      name: mbx4_mbx_error
      width: 1
      type: interrupt
      module_name: mbx4
      desc: mbx4 mbx_error interrupt
      intr_type: IntrType.Event
      default_val: false
      incoming: false
      plic: rv_plic_mio
      outgoing: false
    }
    {
      name: mbx5_mbx_ready
      width: 1
      type: interrupt
      module_name: mbx5
      desc: mbx5 mbx_ready interrupt
      intr_type: IntrType.Event
      default_val: false
      incoming: false
      plic: rv_plic_mio
      outgoing: false
    }
    {
      name: mbx5_mbx_abort
      width: 1
      type: interrupt
      module_name: mbx5
      desc: mbx5 mbx_abort interrupt
      intr_type: IntrType.Event
      default_val: false
      incoming: false
      plic: rv_plic_mio
      outgoing: false
    }
    {
      name: mbx5_mbx_error
      width: 1
      type: interrupt
      module_name: mbx5
      desc: mbx5 mbx_error interrupt
      intr_type: IntrType.Event
      default_val: false
      incoming: false
      plic: rv_plic_mio
      outgoing: false
    }
    {
      name: mbx_pcie0_mbx_ready
      width: 1
      type: interrupt
      module_name: mbx_pcie0
      desc: mbx_pcie0 mbx_ready interrupt
      intr_type: IntrType.Event
      default_val: false
      incoming: false
      plic: rv_plic_mio
      outgoing: false
    }
    {
      name: mbx_pcie0_mbx_abort
      width: 1
      type: interrupt
      module_name: mbx_pcie0
      desc: mbx_pcie0 mbx_abort interrupt
      intr_type: IntrType.Event
      default_val: false
      incoming: false
      plic: rv_plic_mio
      outgoing: false
    }
    {
      name: mbx_pcie0_mbx_error
      width: 1
      type: interrupt
      module_name: mbx_pcie0
      desc: mbx_pcie0 mbx_error interrupt
      intr_type: IntrType.Event
      default_val: false
      incoming: false
      plic: rv_plic_mio
      outgoing: false
    }
    {
      name: MIO_HDR_IPI_FROM_MIO_0
      module_name: MIO_HDR
      type: interrupt
      intr_type: IntrType.Event
      default_val: false
      desc: MIO_HDR IPI_FROM_MIO_0 incoming interrupt
      incoming: true
      width: 1
      plic: rv_plic_mio
      outgoing: false
    }
    {
      name: MIO_HDR_IPI_FROM_MIO_1
      module_name: MIO_HDR
      type: interrupt
      intr_type: IntrType.Event
      default_val: false
      desc: MIO_HDR IPI_FROM_MIO_1 incoming interrupt
      incoming: true
      width: 1
      plic: rv_plic_mio
      outgoing: false
    }
    {
      name: MIO_HDR_IPI_FROM_MIO_2
      module_name: MIO_HDR
      type: interrupt
      intr_type: IntrType.Event
      default_val: false
      desc: MIO_HDR IPI_FROM_MIO_2 incoming interrupt
      incoming: true
      width: 1
      plic: rv_plic_mio
      outgoing: false
    }
    {
      name: MIO_HDR_IPI_FROM_ROT
      module_name: MIO_HDR
      type: interrupt
      intr_type: IntrType.Event
      default_val: false
      desc: MIO_HDR IPI_FROM_ROT incoming interrupt
      incoming: true
      width: 1
      plic: rv_plic_mio
      outgoing: false
    }
    {
      name: MIO_HDR_IPI_FROM_PWC
      module_name: MIO_HDR
      type: interrupt
      intr_type: IntrType.Event
      default_val: false
      desc: MIO_HDR IPI_FROM_PWC incoming interrupt
      incoming: true
      width: 1
      plic: rv_plic_mio
      outgoing: false
    }
    {
      name: MIO_HDR_IPI_FROM_DUC
      module_name: MIO_HDR
      type: interrupt
      intr_type: IntrType.Event
      default_val: false
      desc: MIO_HDR IPI_FROM_DUC incoming interrupt
      incoming: true
      width: 1
      plic: rv_plic_mio
      outgoing: false
    }
    {
      name: LIO_GRP_A_IBEX_IRQ
      module_name: LIO_GRP_A
      type: interrupt
      intr_type: IntrType.Event
      default_val: false
      desc: LIO_GRP_A IBEX_IRQ incoming interrupt
      incoming: true
      width: 1
      plic: rv_plic_mio
      outgoing: false
    }
    {
      name: LIO_GRP_B_IBEX_IRQ
      module_name: LIO_GRP_B
      type: interrupt
      intr_type: IntrType.Event
      default_val: false
      desc: LIO_GRP_B IBEX_IRQ incoming interrupt
      incoming: true
      width: 1
      plic: rv_plic_mio
      outgoing: false
    }
    {
      name: LIO_GRP_C_IBEX_IRQ
      module_name: LIO_GRP_C
      type: interrupt
      intr_type: IntrType.Event
      default_val: false
      desc: LIO_GRP_C IBEX_IRQ incoming interrupt
      incoming: true
      width: 1
      plic: rv_plic_mio
      outgoing: false
    }
  ]
  outgoing_interrupt:
  {
    mio:
    [
      {
        name: racl_ctrl_mio_racl_error
        width: 1
        type: interrupt
        module_name: racl_ctrl_mio
        desc: racl_ctrl_mio racl_error interrupt
        intr_type: IntrType.Status
        default_val: false
        incoming: false
        plic: rv_plic_mio
        outgoing: true
      }
      {
        name: ac_range_check_mio_deny_cnt_reached
        width: 1
        type: interrupt
        module_name: ac_range_check_mio
        desc: ac_range_check_mio deny_cnt_reached interrupt
        intr_type: IntrType.Status
        default_val: false
        incoming: false
        plic: rv_plic_mio
        outgoing: true
      }
    ]
  }
  alert_module: []
  alert_connections:
  {
    module_rv_timer:
    {
      tx_expr: outgoing_alert_mio_tx_o[0:0]
      rx_expr: outgoing_alert_mio_rx_i[0:0]
      async_expr: AsyncOnOutgoingAlertMio[0:0]
      comments:
      [
        External alert group "mio" [0]: fatal_fault
      ]
    }
    module_aon_timer_aon:
    {
      tx_expr: outgoing_alert_mio_tx_o[1:1]
      rx_expr: outgoing_alert_mio_rx_i[1:1]
      async_expr: AsyncOnOutgoingAlertMio[1:1]
      comments:
      [
        External alert group "mio" [1]: fatal_fault
      ]
    }
    module_sram_ctrl_ret_aon:
    {
      tx_expr: outgoing_alert_mio_tx_o[2:2]
      rx_expr: outgoing_alert_mio_rx_i[2:2]
      async_expr: AsyncOnOutgoingAlertMio[2:2]
      comments:
      [
        External alert group "mio" [2]: fatal_error
      ]
    }
    module_rv_dm:
    {
      tx_expr: outgoing_alert_mio_tx_o[3:3]
      rx_expr: outgoing_alert_mio_rx_i[3:3]
      async_expr: AsyncOnOutgoingAlertMio[3:3]
      comments:
      [
        External alert group "mio" [3]: fatal_fault
      ]
    }
    module_rv_plic_mio:
    {
      tx_expr: outgoing_alert_mio_tx_o[4:4]
      rx_expr: outgoing_alert_mio_rx_i[4:4]
      async_expr: AsyncOnOutgoingAlertMio[4:4]
      comments:
      [
        External alert group "mio" [4]: fatal_fault
      ]
    }
    module_sram_ctrl_main:
    {
      tx_expr: outgoing_alert_mio_tx_o[5:5]
      rx_expr: outgoing_alert_mio_rx_i[5:5]
      async_expr: AsyncOnOutgoingAlertMio[5:5]
      comments:
      [
        External alert group "mio" [5]: fatal_error
      ]
    }
    module_sram_ctrl_mbox:
    {
      tx_expr: outgoing_alert_mio_tx_o[6:6]
      rx_expr: outgoing_alert_mio_rx_i[6:6]
      async_expr: AsyncOnOutgoingAlertMio[6:6]
      comments:
      [
        External alert group "mio" [6]: fatal_error
      ]
    }
    module_dma:
    {
      tx_expr: outgoing_alert_mio_tx_o[7:7]
      rx_expr: outgoing_alert_mio_rx_i[7:7]
      async_expr: AsyncOnOutgoingAlertMio[7:7]
      comments:
      [
        External alert group "mio" [7]: fatal_fault
      ]
    }
    module_mbx0:
    {
      tx_expr: outgoing_alert_mio_tx_o[9:8]
      rx_expr: outgoing_alert_mio_rx_i[9:8]
      async_expr: AsyncOnOutgoingAlertMio[9:8]
      comments:
      [
        External alert group "mio" [8]: fatal_fault
        External alert group "mio" [9]: recov_fault
      ]
    }
    module_mbx1:
    {
      tx_expr: outgoing_alert_mio_tx_o[11:10]
      rx_expr: outgoing_alert_mio_rx_i[11:10]
      async_expr: AsyncOnOutgoingAlertMio[11:10]
      comments:
      [
        External alert group "mio" [10]: fatal_fault
        External alert group "mio" [11]: recov_fault
      ]
    }
    module_mbx2:
    {
      tx_expr: outgoing_alert_mio_tx_o[13:12]
      rx_expr: outgoing_alert_mio_rx_i[13:12]
      async_expr: AsyncOnOutgoingAlertMio[13:12]
      comments:
      [
        External alert group "mio" [12]: fatal_fault
        External alert group "mio" [13]: recov_fault
      ]
    }
    module_mbx3:
    {
      tx_expr: outgoing_alert_mio_tx_o[15:14]
      rx_expr: outgoing_alert_mio_rx_i[15:14]
      async_expr: AsyncOnOutgoingAlertMio[15:14]
      comments:
      [
        External alert group "mio" [14]: fatal_fault
        External alert group "mio" [15]: recov_fault
      ]
    }
    module_mbx4:
    {
      tx_expr: outgoing_alert_mio_tx_o[17:16]
      rx_expr: outgoing_alert_mio_rx_i[17:16]
      async_expr: AsyncOnOutgoingAlertMio[17:16]
      comments:
      [
        External alert group "mio" [16]: fatal_fault
        External alert group "mio" [17]: recov_fault
      ]
    }
    module_mbx5:
    {
      tx_expr: outgoing_alert_mio_tx_o[19:18]
      rx_expr: outgoing_alert_mio_rx_i[19:18]
      async_expr: AsyncOnOutgoingAlertMio[19:18]
      comments:
      [
        External alert group "mio" [18]: fatal_fault
        External alert group "mio" [19]: recov_fault
      ]
    }
    module_mbx_pcie0:
    {
      tx_expr: outgoing_alert_mio_tx_o[21:20]
      rx_expr: outgoing_alert_mio_rx_i[21:20]
      async_expr: AsyncOnOutgoingAlertMio[21:20]
      comments:
      [
        External alert group "mio" [20]: fatal_fault
        External alert group "mio" [21]: recov_fault
      ]
    }
    module_racl_ctrl_mio:
    {
      tx_expr: outgoing_alert_mio_tx_o[23:22]
      rx_expr: outgoing_alert_mio_rx_i[23:22]
      async_expr: AsyncOnOutgoingAlertMio[23:22]
      comments:
      [
        External alert group "mio" [22]: fatal_fault
        External alert group "mio" [23]: recov_ctrl_update_err
      ]
    }
    module_ac_range_check_mio:
    {
      tx_expr: outgoing_alert_mio_tx_o[25:24]
      rx_expr: outgoing_alert_mio_rx_i[25:24]
      async_expr: AsyncOnOutgoingAlertMio[25:24]
      comments:
      [
        External alert group "mio" [24]: recov_ctrl_update_err
        External alert group "mio" [25]: fatal_fault
      ]
    }
    module_rv_core_ibex_mio:
    {
      tx_expr: outgoing_alert_mio_tx_o[29:26]
      rx_expr: outgoing_alert_mio_rx_i[29:26]
      async_expr: AsyncOnOutgoingAlertMio[29:26]
      comments:
      [
        External alert group "mio" [26]: fatal_sw_err
        External alert group "mio" [27]: recov_sw_err
        External alert group "mio" [28]: fatal_hw_err
        External alert group "mio" [29]: recov_hw_err
      ]
    }
  }
  interrupt_module:
  [
    rv_timer
    aon_timer_aon
    dma
    mbx0
    mbx1
    mbx2
    mbx3
    mbx4
    mbx5
    mbx_pcie0
  ]
  outgoing_alert_module:
  {
    mio:
    [
      rv_timer
      aon_timer_aon
      sram_ctrl_ret_aon
      rv_dm
      rv_plic_mio
      sram_ctrl_main
      sram_ctrl_mbox
      dma
      mbx0
      mbx1
      mbx2
      mbx3
      mbx4
      mbx5
      mbx_pcie0
      racl_ctrl_mio
      ac_range_check_mio
      rv_core_ibex_mio
    ]
  }
  outgoing_interrupt_module:
  {
    mio:
    [
      racl_ctrl_mio
      ac_range_check_mio
    ]
  }
  alert_lpgs: []
  outgoing_alert_lpgs:
  {
    mio:
    [
      {
        name: clk_ext_io_div4_i_ext_rst_io_div4_0
        clock_group: null
        clock_connection: clk_ext_io_div4_i
        unmanaged_clock: true
        unmanaged_reset: true
        reset_connection:
        {
          name: ext_rst_io_div4
          domain: "0"
        }
      }
      {
        name: clk_ext_main_i_ext_rst_main_0
        clock_group: null
        clock_connection: clk_ext_main_i
        unmanaged_clock: true
        unmanaged_reset: true
        reset_connection:
        {
          name: ext_rst_main
          domain: "0"
        }
      }
    ]
  }
  inter_signal:
  {
    signals:
    [
      {
        name: racl_policies
        desc:
          '''
          Incoming RACL policy vector from a racl_ctrl instance.
          The policy selection vector (parameter) selects the policy for each register.
          '''
        struct: racl_policy_vec
        package: top_racl_pkg
        type: uni
        act: rcv
        width: 1
        inst_name: rv_timer
        default: ""
        top_signame: racl_ctrl_mio_racl_policies
        index: -1
      }
      {
        name: racl_error
        desc: RACL error log information of this module.
        struct: racl_error_log
        package: top_racl_pkg
        type: uni
        act: req
        width: 1
        inst_name: rv_timer
        default: ""
        top_signame: racl_ctrl_mio_racl_error
        index: 0
      }
      {
        name: tl
        struct: tl
        package: tlul_pkg
        type: req_rsp
        act: rsp
        width: 1
        inst_name: rv_timer
        default: ""
        end_idx: -1
        top_signame: rv_timer_tl
        index: -1
      }
      {
        name: nmi_wdog_timer_bark
        struct: logic
        type: uni
        act: req
        width: 1
        default: 1'b0
        inst_name: aon_timer_aon
        package: ""
        end_idx: -1
        top_type: broadcast
        top_signame: aon_timer_aon_nmi_wdog_timer_bark
        index: -1
      }
      {
        name: wkup_req
        struct: logic
        type: uni
        act: req
        width: 1
        default: 1'b0
        inst_name: aon_timer_aon
        index: -1
      }
      {
        name: aon_timer_rst_req
        struct: logic
        type: uni
        act: req
        width: 1
        default: 1'b0
        inst_name: aon_timer_aon
        package: ""
        external: true
        top_signame: aon_timer_rst_req
        conn_type: false
        index: -1
      }
      {
        name: lc_escalate_en
        struct: lc_tx
        package: lc_ctrl_pkg
        type: uni
        act: rcv
        width: 1
        default: lc_ctrl_pkg::Off
        inst_name: aon_timer_aon
        top_signame: mio_soc_proxy_lc_escalate_en
        index: -1
      }
      {
        name: sleep_mode
        struct: logic
        type: uni
        act: rcv
        width: 1
        inst_name: aon_timer_aon
        index: -1
      }
      {
        name: racl_policies
        desc:
          '''
          Incoming RACL policy vector from a racl_ctrl instance.
          The policy selection vector (parameter) selects the policy for each register.
          '''
        struct: racl_policy_vec
        package: top_racl_pkg
        type: uni
        act: rcv
        width: 1
        inst_name: aon_timer_aon
        default: ""
        top_signame: racl_ctrl_mio_racl_policies
        index: -1
      }
      {
        name: racl_error
        desc: RACL error log information of this module.
        struct: racl_error_log
        package: top_racl_pkg
        type: uni
        act: req
        width: 1
        inst_name: aon_timer_aon
        default: ""
        top_signame: racl_ctrl_mio_racl_error
        index: 1
      }
      {
        name: tl
        struct: tl
        package: tlul_pkg
        type: req_rsp
        act: rsp
        width: 1
        inst_name: aon_timer_aon
        default: ""
        end_idx: -1
        top_signame: aon_timer_aon_tl
        index: -1
      }
      {
        name: lc_escalate_en
        desc:
          '''
          Escalation enable signal coming from life cycle controller, used for invalidating
          the latched lc_hw_debug_en state inside the strap sampling logic.
          '''
        struct: lc_tx
        package: lc_ctrl_pkg
        type: uni
        act: req
        width: 1
        default: lc_ctrl_pkg::Off
        inst_name: mio_soc_proxy
        end_idx: -1
        top_type: broadcast
        top_signame: mio_soc_proxy_lc_escalate_en
        index: -1
      }
      {
        name: lc_escalate_en_ext
        desc:
          '''
          Escalation enable signal coming from life cycle controller, used for invalidating
          the latched lc_hw_debug_en state inside the strap sampling logic.
          '''
        struct: lc_tx
        package: lc_ctrl_pkg
        type: uni
        act: rcv
        width: 1
        default: lc_ctrl_pkg::Off
        inst_name: mio_soc_proxy
        external: true
        top_signame: lc_escalate_en_ext
        conn_type: false
        index: -1
      }
      {
        name: lc_hw_debug_en
        desc:
          '''
          Multibit life cycle hardware debug enable signal coming from life cycle controller,
          asserted when the hardware debug mechanisms are enabled in the system.
          '''
        struct: lc_tx
        package: lc_ctrl_pkg
        type: uni
        act: req
        width: 1
        default: lc_ctrl_pkg::Off
        inst_name: mio_soc_proxy
        end_idx: -1
        top_type: broadcast
        top_signame: mio_soc_proxy_lc_hw_debug_en
        index: -1
      }
      {
        name: lc_hw_debug_en_ext
        desc:
          '''
          Multibit life cycle hardware debug enable signal coming from life cycle controller,
          asserted when the hardware debug mechanisms are enabled in the system.
          '''
        struct: lc_tx
        package: lc_ctrl_pkg
        type: uni
        act: rcv
        width: 1
        default: lc_ctrl_pkg::Off
        inst_name: mio_soc_proxy
        external: true
        top_signame: lc_hw_debug_en_ext
        conn_type: false
        index: -1
      }
      {
        name: dma_tl_h2d
        desc: TL-UL host port for the DMA to egress into CTN (request part), synchronous
        struct: tl_h2d
        package: tlul_pkg
        type: uni
        act: rcv
        width: 1
        inst_name: mio_soc_proxy
        default: ""
        end_idx: -1
        top_type: broadcast
        top_signame: mio_soc_proxy_dma_tl_h2d
        index: -1
      }
      {
        name: dma_tl_d2h
        desc: TL-UL host port for the DMA to egress into CTN (response part), synchronous
        struct: tl_d2h
        package: tlul_pkg
        type: uni
        act: req
        width: 1
        inst_name: mio_soc_proxy
        default: ""
        end_idx: -1
        top_type: broadcast
        top_signame: mio_soc_proxy_dma_tl_d2h
        index: -1
      }
      {
        name: muxed_tl_h2d
        desc: Muxed TL-UL host port to go into AC ranges (request part), synchronous
        struct: tl_h2d
        package: tlul_pkg
        type: uni
        act: req
        width: 1
        inst_name: mio_soc_proxy
        default: ""
        end_idx: -1
        top_type: broadcast
        top_signame: mio_soc_proxy_muxed_tl_h2d
        index: -1
      }
      {
        name: muxed_tl_d2h
        desc: Muxed TL-UL host port to go into AC ranges (response part), synchronous
        struct: tl_d2h
        package: tlul_pkg
        type: uni
        act: rcv
        width: 1
        inst_name: mio_soc_proxy
        default: ""
        end_idx: -1
        top_type: broadcast
        top_signame: mio_soc_proxy_muxed_tl_d2h
        index: -1
      }
      {
        name: ac_range_tl_h2d
        desc: TL-UL host port from the AC range, through BAT, to CTN (request part), synchronous
        struct: tl_h2d
        package: tlul_pkg
        type: uni
        act: rcv
        width: 1
        inst_name: mio_soc_proxy
        default: ""
        top_signame: ac_range_check_mio_ctn_filtered_tl_h2d
        index: -1
      }
      {
        name: ac_range_tl_d2h
        desc: TL-UL host port from the AC range, through BAT, to CTN(response part), synchronous
        struct: tl_d2h
        package: tlul_pkg
        type: uni
        act: req
        width: 1
        inst_name: mio_soc_proxy
        default: ""
        top_signame: ac_range_check_mio_ctn_filtered_tl_d2h
        index: -1
      }
      {
        name: ctn_tl_h2d
        desc: TL-UL host port for egress into CTN (request part), synchronous
        struct: tl_h2d
        package: tlul_pkg
        type: uni
        act: req
        width: 1
        inst_name: mio_soc_proxy
        default: ""
        external: true
        top_signame: ctn_tl_h2d
        conn_type: false
        index: -1
      }
      {
        name: ctn_tl_d2h
        desc: TL-UL host port for egress into CTN (response part), synchronous
        struct: tl_d2h
        package: tlul_pkg
        type: uni
        act: rcv
        width: 1
        inst_name: mio_soc_proxy
        default: ""
        external: true
        top_signame: ctn_tl_d2h
        conn_type: false
        index: -1
      }
      {
        name: soc_lsio_trigger
        desc: LSIO trigger signal from SoC, synchronous
        struct: logic
        type: uni
        act: rcv
        width: 8
        inst_name: mio_soc_proxy
        default: ""
        package: ""
        external: true
        top_signame: soc_lsio_trigger
        conn_type: false
        index: -1
      }
      {
        name: dma_lsio_trigger
        desc: Collated synchronous LSIO trigger signals for DMA
        struct: lsio_trigger
        package: dma_pkg
        type: uni
        act: req
        width: 1
        inst_name: mio_soc_proxy
        default: ""
        top_signame: dma_lsio_trigger
        index: -1
      }
      {
        name: integrator_id
        desc: Integrator ID signal used in BAT
        struct: logic
        type: uni
        act: rcv
        width: 4
        inst_name: mio_soc_proxy
        default: ""
        package: ""
        external: true
        top_signame: integrator_id
        conn_type: false
        index: -1
      }
      {
        name: mubi8_true
        struct: mubi8
        package: prim_mubi_pkg
        type: uni
        act: req
        width: 1
        default: prim_mubi_pkg::MuBi8False
        inst_name: mio_soc_proxy
        top_signame: sram_ctrl_main_otp_en_sram_ifetch
        index: -1
      }
      {
        name: ctn_tl
        struct: tl
        package: tlul_pkg
        type: req_rsp
        act: rsp
        width: 1
        inst_name: mio_soc_proxy
        default: ""
        end_idx: -1
        top_signame: mio_soc_proxy_ctn_tl
        index: -1
      }
      {
        name: sram_otp_key
        struct: sram_otp_key
        package: otp_ctrl_pkg
        type: req_rsp
        act: req
        width: 1
        inst_name: sram_ctrl_ret_aon
        index: -1
      }
      {
        name: cfg
        struct: ram_1p_cfg
        package: prim_ram_1p_pkg
        type: uni
        act: rcv
        width:
        {
          name: NumRamInst
          desc: Number of internal RAM instances. Must be the same as ceil(MemSizeRam / InstSize) .
          param_type: int
          unpacked_dimensions: null
          default: 1
          local: false
          expose: true
          name_top: SramCtrlRetAonNumRamInst
        }
        default: "'0"
        inst_name: sram_ctrl_ret_aon
        external: true
        top_signame: sram_ctrl_ret_aon_ram_1p_cfg
        conn_type: false
        index: -1
      }
      {
        name: cfg_rsp
        struct: ram_1p_cfg_rsp
        package: prim_ram_1p_pkg
        type: uni
        act: req
        width:
        {
          name: NumRamInst
          desc: Number of internal RAM instances. Must be the same as ceil(MemSizeRam / InstSize) .
          param_type: int
          unpacked_dimensions: null
          default: 1
          local: false
          expose: true
          name_top: SramCtrlRetAonNumRamInst
        }
        default: "'0"
        inst_name: sram_ctrl_ret_aon
        external: true
        top_signame: sram_ctrl_ret_aon_ram_1p_cfg_rsp
        conn_type: false
        index: -1
      }
      {
        name: lc_escalate_en
        struct: lc_tx
        package: lc_ctrl_pkg
        type: uni
        act: rcv
        width: 1
        default: lc_ctrl_pkg::Off
        inst_name: sram_ctrl_ret_aon
        top_signame: mio_soc_proxy_lc_escalate_en
        index: -1
      }
      {
        name: lc_hw_debug_en
        struct: lc_tx
        package: lc_ctrl_pkg
        type: uni
        act: rcv
        width: 1
        default: lc_ctrl_pkg::Off
        inst_name: sram_ctrl_ret_aon
        top_signame: mio_soc_proxy_lc_hw_debug_en
        index: -1
      }
      {
        name: otp_en_sram_ifetch
        struct: mubi8
        package: prim_mubi_pkg
        type: uni
        act: rcv
        width: 1
        default: prim_mubi_pkg::MuBi8False
        inst_name: sram_ctrl_ret_aon
        index: -1
      }
      {
        name: racl_policies
        desc:
          '''
          Incoming RACL policy vector from a racl_ctrl instance.
          The policy selection vector (parameter) selects the policy for each register.
          '''
        struct: racl_policy_vec
        package: top_racl_pkg
        type: uni
        act: rcv
        width: 1
        inst_name: sram_ctrl_ret_aon
        default: ""
        top_signame: racl_ctrl_mio_racl_policies
        index: -1
      }
      {
        name: racl_error
        desc: RACL error log information of this module.
        struct: racl_error_log
        package: top_racl_pkg
        type: uni
        act: req
        width: 1
        inst_name: sram_ctrl_ret_aon
        default: ""
        top_signame: racl_ctrl_mio_racl_error
        index: 2
      }
      {
        name: sram_rerror
        desc: SRAM read error indicating correctable and uncorrectable ECC errors.
        struct: sram_error_t
        package: sram_ctrl_pkg
        type: uni
        act: req
        width: 1
        inst_name: sram_ctrl_ret_aon
        index: -1
      }
      {
        name: regs_tl
        struct: tl
        package: tlul_pkg
        type: req_rsp
        act: rsp
        width: 1
        inst_name: sram_ctrl_ret_aon
        default: ""
        end_idx: -1
        top_signame: sram_ctrl_ret_aon_regs_tl
        index: -1
      }
      {
        name: ram_tl
        struct: tl
        package: tlul_pkg
        type: req_rsp
        act: rsp
        width: 1
        inst_name: sram_ctrl_ret_aon
        default: ""
        end_idx: -1
        top_signame: sram_ctrl_ret_aon_ram_tl
        index: -1
      }
      {
        name: next_dm_addr
        desc:
          '''
          32bit word address of the next debug module.
          Set to 0x0 if this is the last debug module in the chain.
          '''
        struct: next_dm_addr
        package: rv_dm_pkg
        type: uni
        act: rcv
        width: 1
        default: "'0"
        inst_name: rv_dm
        external: true
        top_signame: rv_dm_next_dm_addr
        conn_type: false
        index: -1
      }
      {
        name: jtag
        desc: JTAG signals for the RISC-V TAP.
        struct: jtag
        package: jtag_pkg
        type: req_rsp
        act: rsp
        width: 1
        inst_name: rv_dm
        index: -1
      }
      {
        name: lc_init_done
        desc: Lifecycle initialization done signal coming from life cycle controller.
        struct: lc_tx
        package: lc_ctrl_pkg
        type: uni
        act: rcv
        width: 1
        default: lc_ctrl_pkg::Off
        inst_name: rv_dm
        index: -1
      }
      {
        name: lc_hw_debug_clr
        desc:
          '''
          Multibit life cycle hardware debug clear signal coming from life cycle controller,
          asserted when the hardware debug mechanism was enabled and gets disabled.
          '''
        struct: lc_tx
        package: lc_ctrl_pkg
        type: uni
        act: rcv
        width: 1
        default: lc_ctrl_pkg::Off
        inst_name: rv_dm
        index: -1
      }
      {
        name: lc_hw_debug_en
        desc:
          '''
          Multibit life cycle hardware debug enable signal coming from life cycle controller,
          asserted when the hardware debug mechanisms are enabled in the system.
          '''
        struct: lc_tx
        package: lc_ctrl_pkg
        type: uni
        act: rcv
        width: 1
        default: lc_ctrl_pkg::Off
        inst_name: rv_dm
        top_signame: mio_soc_proxy_lc_hw_debug_en
        index: -1
      }
      {
        name: lc_dft_en
        desc:
          '''
          Multibit life cycle hardware debug enable signal coming from life cycle controller,
          asserted when the DFT mechanisms are enabled in the system.
          '''
        struct: lc_tx
        package: lc_ctrl_pkg
        type: uni
        act: rcv
        width: 1
        default: lc_ctrl_pkg::Off
        inst_name: rv_dm
        index: -1
      }
      {
        name: pinmux_hw_debug_en
        desc:
          '''
          Multibit life cycle hardware debug enable signal coming from pinmux.
          This is a latched version of the lc_hw_debug_en signal and is only used to
          gate the JTAG / TAP side of the RV_DM. It is used to keep a debug session live
          while the rest of the system undergoes an NDM reset.
          '''
        struct: lc_tx
        package: lc_ctrl_pkg
        type: uni
        act: rcv
        width: 1
        default: lc_ctrl_pkg::Off
        inst_name: rv_dm
        index: -1
      }
      {
        name: otp_dis_rv_dm_late_debug
        struct: mubi8
        package: prim_mubi_pkg
        type: uni
        act: rcv
        width: 1
        default: prim_mubi_pkg::MuBi8False
        inst_name: rv_dm
        top_signame: rv_dm_otp_dis_rv_dm_late_debug
        index: -1
      }
      {
        name: unavailable
        desc:
          '''
          This signal indicates to the debug module that the main processor is not available
          for debug (e.g. due to a low-power state).
          '''
        struct: logic
        type: uni
        act: rcv
        width: 1
        default: 1'b0
        inst_name: rv_dm
        index: -1
      }
      {
        name: ndmreset_req
        desc: Non-debug module reset request going to the system reset infrastructure.
        struct: logic
        type: uni
        act: req
        width: 1
        inst_name: rv_dm
        index: -1
      }
      {
        name: dmactive
        desc:
          '''
          This signal indicates whether the debug module is active and can be used to prevent
          power down of the core and bus-attached peripherals.
          '''
        struct: logic
        type: uni
        act: req
        width: 1
        inst_name: rv_dm
        index: -1
      }
      {
        name: debug_req
        desc: This is the debug request interrupt going to the main processor.
        struct: logic [rv_dm_reg_pkg::NrHarts-1:0]
        type: uni
        act: req
        width: 1
        inst_name: rv_dm
        default: ""
        package: ""
        end_idx: -1
        top_type: broadcast
        top_signame: rv_dm_debug_req
        index: -1
      }
      {
        name: lc_escalate_en
        desc:
          '''
          Escalation enable signal coming from life cycle controller, used for invalidating
          the latched lc_hw_debug_en state inside the strap sampling logic.
          '''
        struct: lc_tx
        package: lc_ctrl_pkg
        type: uni
        act: rcv
        width: 1
        default: lc_ctrl_pkg::Off
        inst_name: rv_dm
        top_signame: mio_soc_proxy_lc_escalate_en
        index: -1
      }
      {
        name: lc_check_byp_en
        desc:
          '''
          Check bypass enable signal coming from life cycle controller, used for invalidating
          the latched lc_hw_debug_en state inside the strap sampling logic. This signal is asserted
          whenever the life cycle controller performs a life cycle transition. Its main use is
          to skip any background checks inside the life cycle partition of the OTP controller while
          a life cycle transition is in progress.
          '''
        struct: lc_tx
        package: lc_ctrl_pkg
        type: uni
        act: rcv
        width: 1
        default: lc_ctrl_pkg::Off
        inst_name: rv_dm
        external: true
        top_signame: lc_check_byp_en
        conn_type: false
        index: -1
      }
      {
        name: strap_en
        desc: This signal is pulsed high by the power manager after reset in order to sample the HW straps.
        struct: logic
        type: uni
        act: rcv
        width: 1
        default: 1'b0
        inst_name: rv_dm
        package: ""
        external: true
        top_signame: rv_dm_strap_en
        conn_type: false
        index: -1
      }
      {
        name: strap_en_override
        desc:
          '''
          This signal transitions from 0 -> 1 by the lc_ctrl manager after volatile RAW_UNLOCK in order to re-sample the HW straps.
          The signal must stay at 1 until reset.
          Note that this is only used in test chips when SecVolatileRawUnlockEn = 1.
          Otherwise this signal is unused.
          '''
        struct: logic
        type: uni
        act: rcv
        width: 1
        default: 1'b0
        inst_name: rv_dm
        package: ""
        external: true
        top_signame: rv_dm_strap_en_override
        conn_type: false
        index: -1
      }
      {
        name: racl_policies
        desc:
          '''
          Incoming RACL policy vector from a racl_ctrl instance.
          The policy selection vector (parameter) selects the policy for each register.
          '''
        struct: racl_policy_vec
        package: top_racl_pkg
        type: uni
        act: rcv
        width: 1
        inst_name: rv_dm
        default: ""
        top_signame: racl_ctrl_mio_racl_policies
        index: -1
      }
      {
        name: racl_error
        desc: RACL error log information of this module.
        struct: racl_error_log
        package: top_racl_pkg
        type: uni
        act: req
        width: 1
        inst_name: rv_dm
        default: ""
        top_signame: racl_ctrl_mio_racl_error
        index: 3
      }
      {
        name: sba_tl_h
        struct: tl
        package: tlul_pkg
        type: req_rsp
        act: req
        width: 1
        inst_name: rv_dm
        default: ""
        top_signame: mio_main_tl_rv_dm__sba
        index: -1
      }
      {
        name: regs_tl_d
        struct: tl
        package: tlul_pkg
        type: req_rsp
        act: rsp
        width: 1
        inst_name: rv_dm
        default: ""
        end_idx: -1
        top_signame: rv_dm_regs_tl_d
        index: -1
      }
      {
        name: mem_tl_d
        struct: tl
        package: tlul_pkg
        type: req_rsp
        act: rsp
        width: 1
        inst_name: rv_dm
        default: ""
        end_idx: -1
        top_signame: rv_dm_mem_tl_d
        index: -1
      }
      {
        name: dbg_tl_d
        struct: tl
        package: tlul_pkg
        type: req_rsp
        act: rsp
        width: 1
        inst_name: rv_dm
        default: ""
        external: true
        top_signame: rv_dm_dbg
        conn_type: false
        index: -1
      }
      {
        name: irq
        struct: logic
        type: uni
        act: req
        width: 1
        inst_name: rv_plic_mio
        default: ""
        package: ""
        end_idx: -1
        top_type: broadcast
        top_signame: rv_plic_mio_irq
        index: -1
      }
      {
        name: irq_id
        struct: logic
        type: uni
        act: req
        width: 1
        inst_name: rv_plic_mio
        index: -1
      }
      {
        name: msip
        struct: logic
        type: uni
        act: req
        width: 1
        inst_name: rv_plic_mio
        default: ""
        package: ""
        end_idx: -1
        top_type: broadcast
        top_signame: rv_plic_mio_msip
        index: -1
      }
      {
        name: racl_policies
        desc:
          '''
          Incoming RACL policy vector from a racl_ctrl instance.
          The policy selection vector (parameter) selects the policy for each register.
          '''
        struct: racl_policy_vec
        package: top_racl_pkg
        type: uni
        act: rcv
        width: 1
        inst_name: rv_plic_mio
        default: ""
        top_signame: racl_ctrl_mio_racl_policies
        index: -1
      }
      {
        name: racl_error
        desc: RACL error log information of this module.
        struct: racl_error_log
        package: top_racl_pkg
        type: uni
        act: req
        width: 1
        inst_name: rv_plic_mio
        default: ""
        top_signame: racl_ctrl_mio_racl_error
        index: 4
      }
      {
        name: tl
        struct: tl
        package: tlul_pkg
        type: req_rsp
        act: rsp
        width: 1
        inst_name: rv_plic_mio
        default: ""
        end_idx: -1
        top_signame: rv_plic_mio_tl
        index: -1
      }
      {
        name: sram_otp_key
        struct: sram_otp_key
        package: otp_ctrl_pkg
        type: req_rsp
        act: req
        width: 1
        inst_name: sram_ctrl_main
        index: -1
      }
      {
        name: cfg
        struct: ram_1p_cfg
        package: prim_ram_1p_pkg
        type: uni
        act: rcv
        width:
        {
          name: NumRamInst
          desc: Number of internal RAM instances. Must be the same as ceil(MemSizeRam / InstSize) .
          param_type: int
          unpacked_dimensions: null
          default: 1
          local: false
          expose: true
          name_top: SramCtrlMainNumRamInst
        }
        default: "'0"
        inst_name: sram_ctrl_main
        external: true
        top_signame: sram_ctrl_main_ram_1p_cfg
        conn_type: false
        index: -1
      }
      {
        name: cfg_rsp
        struct: ram_1p_cfg_rsp
        package: prim_ram_1p_pkg
        type: uni
        act: req
        width:
        {
          name: NumRamInst
          desc: Number of internal RAM instances. Must be the same as ceil(MemSizeRam / InstSize) .
          param_type: int
          unpacked_dimensions: null
          default: 1
          local: false
          expose: true
          name_top: SramCtrlMainNumRamInst
        }
        default: "'0"
        inst_name: sram_ctrl_main
        external: true
        top_signame: sram_ctrl_main_ram_1p_cfg_rsp
        conn_type: false
        index: -1
      }
      {
        name: lc_escalate_en
        struct: lc_tx
        package: lc_ctrl_pkg
        type: uni
        act: rcv
        width: 1
        default: lc_ctrl_pkg::Off
        inst_name: sram_ctrl_main
        top_signame: mio_soc_proxy_lc_escalate_en
        index: -1
      }
      {
        name: lc_hw_debug_en
        struct: lc_tx
        package: lc_ctrl_pkg
        type: uni
        act: rcv
        width: 1
        default: lc_ctrl_pkg::Off
        inst_name: sram_ctrl_main
        top_signame: mio_soc_proxy_lc_hw_debug_en
        index: -1
      }
      {
        name: otp_en_sram_ifetch
        struct: mubi8
        package: prim_mubi_pkg
        type: uni
        act: rcv
        width: 1
        default: prim_mubi_pkg::MuBi8False
        inst_name: sram_ctrl_main
        end_idx: -1
        top_type: broadcast
        top_signame: sram_ctrl_main_otp_en_sram_ifetch
        index: -1
      }
      {
        name: racl_policies
        desc:
          '''
          Incoming RACL policy vector from a racl_ctrl instance.
          The policy selection vector (parameter) selects the policy for each register.
          '''
        struct: racl_policy_vec
        package: top_racl_pkg
        type: uni
        act: rcv
        width: 1
        inst_name: sram_ctrl_main
        default: ""
        top_signame: racl_ctrl_mio_racl_policies
        index: -1
      }
      {
        name: racl_error
        desc: RACL error log information of this module.
        struct: racl_error_log
        package: top_racl_pkg
        type: uni
        act: req
        width: 1
        inst_name: sram_ctrl_main
        default: ""
        top_signame: racl_ctrl_mio_racl_error
        index: 5
      }
      {
        name: sram_rerror
        desc: SRAM read error indicating correctable and uncorrectable ECC errors.
        struct: sram_error_t
        package: sram_ctrl_pkg
        type: uni
        act: req
        width: 1
        inst_name: sram_ctrl_main
        index: -1
      }
      {
        name: regs_tl
        struct: tl
        package: tlul_pkg
        type: req_rsp
        act: rsp
        width: 1
        inst_name: sram_ctrl_main
        default: ""
        end_idx: -1
        top_signame: sram_ctrl_main_regs_tl
        index: -1
      }
      {
        name: ram_tl
        struct: tl
        package: tlul_pkg
        type: req_rsp
        act: rsp
        width: 1
        inst_name: sram_ctrl_main
        default: ""
        end_idx: -1
        top_signame: sram_ctrl_main_ram_tl
        index: -1
      }
      {
        name: sram_otp_key
        struct: sram_otp_key
        package: otp_ctrl_pkg
        type: req_rsp
        act: req
        width: 1
        inst_name: sram_ctrl_mbox
        index: -1
      }
      {
        name: cfg
        struct: ram_1p_cfg
        package: prim_ram_1p_pkg
        type: uni
        act: rcv
        width:
        {
          name: NumRamInst
          desc: Number of internal RAM instances. Must be the same as ceil(MemSizeRam / InstSize) .
          param_type: int
          unpacked_dimensions: null
          default: 1
          local: false
          expose: true
          name_top: SramCtrlMboxNumRamInst
        }
        default: "'0"
        inst_name: sram_ctrl_mbox
        external: true
        top_signame: sram_ctrl_mbox_ram_1p_cfg
        conn_type: false
        index: -1
      }
      {
        name: cfg_rsp
        struct: ram_1p_cfg_rsp
        package: prim_ram_1p_pkg
        type: uni
        act: req
        width:
        {
          name: NumRamInst
          desc: Number of internal RAM instances. Must be the same as ceil(MemSizeRam / InstSize) .
          param_type: int
          unpacked_dimensions: null
          default: 1
          local: false
          expose: true
          name_top: SramCtrlMboxNumRamInst
        }
        default: "'0"
        inst_name: sram_ctrl_mbox
        external: true
        top_signame: sram_ctrl_mbox_ram_1p_cfg_rsp
        conn_type: false
        index: -1
      }
      {
        name: lc_escalate_en
        struct: lc_tx
        package: lc_ctrl_pkg
        type: uni
        act: rcv
        width: 1
        default: lc_ctrl_pkg::Off
        inst_name: sram_ctrl_mbox
        top_signame: mio_soc_proxy_lc_escalate_en
        index: -1
      }
      {
        name: lc_hw_debug_en
        struct: lc_tx
        package: lc_ctrl_pkg
        type: uni
        act: rcv
        width: 1
        default: lc_ctrl_pkg::Off
        inst_name: sram_ctrl_mbox
        top_signame: mio_soc_proxy_lc_hw_debug_en
        index: -1
      }
      {
        name: otp_en_sram_ifetch
        struct: mubi8
        package: prim_mubi_pkg
        type: uni
        act: rcv
        width: 1
        default: prim_mubi_pkg::MuBi8False
        inst_name: sram_ctrl_mbox
        index: -1
      }
      {
        name: racl_policies
        desc:
          '''
          Incoming RACL policy vector from a racl_ctrl instance.
          The policy selection vector (parameter) selects the policy for each register.
          '''
        struct: racl_policy_vec
        package: top_racl_pkg
        type: uni
        act: rcv
        width: 1
        inst_name: sram_ctrl_mbox
        default: ""
        top_signame: racl_ctrl_mio_racl_policies
        index: -1
      }
      {
        name: racl_error
        desc: RACL error log information of this module.
        struct: racl_error_log
        package: top_racl_pkg
        type: uni
        act: req
        width: 1
        inst_name: sram_ctrl_mbox
        default: ""
        top_signame: racl_ctrl_mio_racl_error
        index: 6
      }
      {
        name: sram_rerror
        desc: SRAM read error indicating correctable and uncorrectable ECC errors.
        struct: sram_error_t
        package: sram_ctrl_pkg
        type: uni
        act: req
        width: 1
        inst_name: sram_ctrl_mbox
        index: -1
      }
      {
        name: regs_tl
        struct: tl
        package: tlul_pkg
        type: req_rsp
        act: rsp
        width: 1
        inst_name: sram_ctrl_mbox
        default: ""
        end_idx: -1
        top_signame: sram_ctrl_mbox_regs_tl
        index: -1
      }
      {
        name: ram_tl
        struct: tl
        package: tlul_pkg
        type: req_rsp
        act: rsp
        width: 1
        inst_name: sram_ctrl_mbox
        default: ""
        end_idx: -1
        top_signame: sram_ctrl_mbox_ram_tl
        index: -1
      }
      {
        name: lsio_trigger
        struct: lsio_trigger
        package: dma_pkg
        type: uni
        act: rcv
        width: 1
        inst_name: dma
        default: ""
        end_idx: -1
        top_type: broadcast
        top_signame: dma_lsio_trigger
        index: -1
      }
      {
        name: sys
        desc: SoC System Bus (requests and responses), synchronous
        struct: sys
        package: dma_pkg
        type: req_rsp
        act: req
        width: 1
        inst_name: dma
        default: ""
        external: true
        top_signame: dma_sys
        conn_type: false
        index: -1
      }
      {
        name: ctn_tl_h2d
        desc: TL-UL host port for egress into CTN (request part), synchronous
        struct: tl_h2d
        package: tlul_pkg
        type: uni
        act: req
        width: 1
        inst_name: dma
        default: ""
        top_signame: mio_soc_proxy_dma_tl_h2d
        index: -1
      }
      {
        name: ctn_tl_d2h
        desc: TL-UL host port for egress into CTN (response part), synchronous
        struct: tl_d2h
        package: tlul_pkg
        type: uni
        act: rcv
        width: 1
        inst_name: dma
        default: ""
        top_signame: mio_soc_proxy_dma_tl_d2h
        index: -1
      }
      {
        name: racl_policies
        desc:
          '''
          Incoming RACL policy vector from a racl_ctrl instance.
          The policy selection vector (parameter) selects the policy for each register.
          '''
        struct: racl_policy_vec
        package: top_racl_pkg
        type: uni
        act: rcv
        width: 1
        inst_name: dma
        default: ""
        top_signame: racl_ctrl_mio_racl_policies
        index: -1
      }
      {
        name: racl_error
        desc: RACL error log information of this module.
        struct: racl_error_log
        package: top_racl_pkg
        type: uni
        act: req
        width: 1
        inst_name: dma
        default: ""
        top_signame: racl_ctrl_mio_racl_error
        index: 7
      }
      {
        name: host_tl_h
        struct: tl
        package: tlul_pkg
        type: req_rsp
        act: req
        width: 1
        inst_name: dma
        default: ""
        top_signame: mio_main_tl_dma__host
        index: -1
      }
      {
        name: tl_d
        struct: tl
        package: tlul_pkg
        type: req_rsp
        act: rsp
        width: 1
        inst_name: dma
        default: ""
        end_idx: -1
        top_signame: dma_tl_d
        index: -1
      }
      {
        name: doe_intr_support
        struct: logic
        type: uni
        act: req
        width: 1
        default: 1'b0
        inst_name: mbx0
        index: -1
      }
      {
        name: doe_intr_en
        struct: logic
        type: uni
        act: req
        width: 1
        default: 1'b0
        inst_name: mbx0
        index: -1
      }
      {
        name: doe_intr
        struct: logic
        type: uni
        act: req
        width: 1
        default: 1'b0
        inst_name: mbx0
        index: -1
      }
      {
        name: doe_async_msg_support
        struct: logic
        type: uni
        act: req
        width: 1
        default: 1'b0
        inst_name: mbx0
        index: -1
      }
      {
        name: racl_policies
        desc:
          '''
          Incoming RACL policy vector from a racl_ctrl instance.
          The policy selection vector (parameter) selects the policy for each register.
          '''
        struct: racl_policy_vec
        package: top_racl_pkg
        type: uni
        act: rcv
        width: 1
        inst_name: mbx0
        default: ""
        top_signame: racl_ctrl_mio_racl_policies
        index: -1
      }
      {
        name: racl_error
        desc: RACL error log information of this module.
        struct: racl_error_log
        package: top_racl_pkg
        type: uni
        act: req
        width: 1
        inst_name: mbx0
        default: ""
        top_signame: racl_ctrl_mio_racl_error
        index: 8
      }
      {
        name: sram_tl_h
        struct: tl
        package: tlul_pkg
        type: req_rsp
        act: req
        width: 1
        inst_name: mbx0
        default: ""
        top_signame: mio_main_tl_mbx0__sram
        index: -1
      }
      {
        name: core_tl_d
        struct: tl
        package: tlul_pkg
        type: req_rsp
        act: rsp
        width: 1
        inst_name: mbx0
        default: ""
        end_idx: -1
        top_signame: mbx0_core_tl_d
        index: -1
      }
      {
        name: soc_tl_d
        struct: tl
        package: tlul_pkg
        type: req_rsp
        act: rsp
        width: 1
        inst_name: mbx0
        default: ""
        end_idx: -1
        top_signame: mbx0_soc_tl_d
        index: -1
      }
      {
        name: doe_intr_support
        struct: logic
        type: uni
        act: req
        width: 1
        default: 1'b0
        inst_name: mbx1
        index: -1
      }
      {
        name: doe_intr_en
        struct: logic
        type: uni
        act: req
        width: 1
        default: 1'b0
        inst_name: mbx1
        index: -1
      }
      {
        name: doe_intr
        struct: logic
        type: uni
        act: req
        width: 1
        default: 1'b0
        inst_name: mbx1
        index: -1
      }
      {
        name: doe_async_msg_support
        struct: logic
        type: uni
        act: req
        width: 1
        default: 1'b0
        inst_name: mbx1
        index: -1
      }
      {
        name: racl_policies
        desc:
          '''
          Incoming RACL policy vector from a racl_ctrl instance.
          The policy selection vector (parameter) selects the policy for each register.
          '''
        struct: racl_policy_vec
        package: top_racl_pkg
        type: uni
        act: rcv
        width: 1
        inst_name: mbx1
        default: ""
        top_signame: racl_ctrl_mio_racl_policies
        index: -1
      }
      {
        name: racl_error
        desc: RACL error log information of this module.
        struct: racl_error_log
        package: top_racl_pkg
        type: uni
        act: req
        width: 1
        inst_name: mbx1
        default: ""
        top_signame: racl_ctrl_mio_racl_error
        index: 9
      }
      {
        name: sram_tl_h
        struct: tl
        package: tlul_pkg
        type: req_rsp
        act: req
        width: 1
        inst_name: mbx1
        default: ""
        top_signame: mio_main_tl_mbx1__sram
        index: -1
      }
      {
        name: core_tl_d
        struct: tl
        package: tlul_pkg
        type: req_rsp
        act: rsp
        width: 1
        inst_name: mbx1
        default: ""
        end_idx: -1
        top_signame: mbx1_core_tl_d
        index: -1
      }
      {
        name: soc_tl_d
        struct: tl
        package: tlul_pkg
        type: req_rsp
        act: rsp
        width: 1
        inst_name: mbx1
        default: ""
        end_idx: -1
        top_signame: mbx1_soc_tl_d
        index: -1
      }
      {
        name: doe_intr_support
        struct: logic
        type: uni
        act: req
        width: 1
        default: 1'b0
        inst_name: mbx2
        index: -1
      }
      {
        name: doe_intr_en
        struct: logic
        type: uni
        act: req
        width: 1
        default: 1'b0
        inst_name: mbx2
        index: -1
      }
      {
        name: doe_intr
        struct: logic
        type: uni
        act: req
        width: 1
        default: 1'b0
        inst_name: mbx2
        index: -1
      }
      {
        name: doe_async_msg_support
        struct: logic
        type: uni
        act: req
        width: 1
        default: 1'b0
        inst_name: mbx2
        index: -1
      }
      {
        name: racl_policies
        desc:
          '''
          Incoming RACL policy vector from a racl_ctrl instance.
          The policy selection vector (parameter) selects the policy for each register.
          '''
        struct: racl_policy_vec
        package: top_racl_pkg
        type: uni
        act: rcv
        width: 1
        inst_name: mbx2
        default: ""
        top_signame: racl_ctrl_mio_racl_policies
        index: -1
      }
      {
        name: racl_error
        desc: RACL error log information of this module.
        struct: racl_error_log
        package: top_racl_pkg
        type: uni
        act: req
        width: 1
        inst_name: mbx2
        default: ""
        top_signame: racl_ctrl_mio_racl_error
        index: 10
      }
      {
        name: sram_tl_h
        struct: tl
        package: tlul_pkg
        type: req_rsp
        act: req
        width: 1
        inst_name: mbx2
        default: ""
        top_signame: mio_main_tl_mbx2__sram
        index: -1
      }
      {
        name: core_tl_d
        struct: tl
        package: tlul_pkg
        type: req_rsp
        act: rsp
        width: 1
        inst_name: mbx2
        default: ""
        end_idx: -1
        top_signame: mbx2_core_tl_d
        index: -1
      }
      {
        name: soc_tl_d
        struct: tl
        package: tlul_pkg
        type: req_rsp
        act: rsp
        width: 1
        inst_name: mbx2
        default: ""
        end_idx: -1
        top_signame: mbx2_soc_tl_d
        index: -1
      }
      {
        name: doe_intr_support
        struct: logic
        type: uni
        act: req
        width: 1
        default: 1'b0
        inst_name: mbx3
        index: -1
      }
      {
        name: doe_intr_en
        struct: logic
        type: uni
        act: req
        width: 1
        default: 1'b0
        inst_name: mbx3
        index: -1
      }
      {
        name: doe_intr
        struct: logic
        type: uni
        act: req
        width: 1
        default: 1'b0
        inst_name: mbx3
        index: -1
      }
      {
        name: doe_async_msg_support
        struct: logic
        type: uni
        act: req
        width: 1
        default: 1'b0
        inst_name: mbx3
        index: -1
      }
      {
        name: racl_policies
        desc:
          '''
          Incoming RACL policy vector from a racl_ctrl instance.
          The policy selection vector (parameter) selects the policy for each register.
          '''
        struct: racl_policy_vec
        package: top_racl_pkg
        type: uni
        act: rcv
        width: 1
        inst_name: mbx3
        default: ""
        top_signame: racl_ctrl_mio_racl_policies
        index: -1
      }
      {
        name: racl_error
        desc: RACL error log information of this module.
        struct: racl_error_log
        package: top_racl_pkg
        type: uni
        act: req
        width: 1
        inst_name: mbx3
        default: ""
        top_signame: racl_ctrl_mio_racl_error
        index: 11
      }
      {
        name: sram_tl_h
        struct: tl
        package: tlul_pkg
        type: req_rsp
        act: req
        width: 1
        inst_name: mbx3
        default: ""
        top_signame: mio_main_tl_mbx3__sram
        index: -1
      }
      {
        name: core_tl_d
        struct: tl
        package: tlul_pkg
        type: req_rsp
        act: rsp
        width: 1
        inst_name: mbx3
        default: ""
        end_idx: -1
        top_signame: mbx3_core_tl_d
        index: -1
      }
      {
        name: soc_tl_d
        struct: tl
        package: tlul_pkg
        type: req_rsp
        act: rsp
        width: 1
        inst_name: mbx3
        default: ""
        end_idx: -1
        top_signame: mbx3_soc_tl_d
        index: -1
      }
      {
        name: doe_intr_support
        struct: logic
        type: uni
        act: req
        width: 1
        default: 1'b0
        inst_name: mbx4
        index: -1
      }
      {
        name: doe_intr_en
        struct: logic
        type: uni
        act: req
        width: 1
        default: 1'b0
        inst_name: mbx4
        index: -1
      }
      {
        name: doe_intr
        struct: logic
        type: uni
        act: req
        width: 1
        default: 1'b0
        inst_name: mbx4
        index: -1
      }
      {
        name: doe_async_msg_support
        struct: logic
        type: uni
        act: req
        width: 1
        default: 1'b0
        inst_name: mbx4
        index: -1
      }
      {
        name: racl_policies
        desc:
          '''
          Incoming RACL policy vector from a racl_ctrl instance.
          The policy selection vector (parameter) selects the policy for each register.
          '''
        struct: racl_policy_vec
        package: top_racl_pkg
        type: uni
        act: rcv
        width: 1
        inst_name: mbx4
        default: ""
        top_signame: racl_ctrl_mio_racl_policies
        index: -1
      }
      {
        name: racl_error
        desc: RACL error log information of this module.
        struct: racl_error_log
        package: top_racl_pkg
        type: uni
        act: req
        width: 1
        inst_name: mbx4
        default: ""
        top_signame: racl_ctrl_mio_racl_error
        index: 12
      }
      {
        name: sram_tl_h
        struct: tl
        package: tlul_pkg
        type: req_rsp
        act: req
        width: 1
        inst_name: mbx4
        default: ""
        top_signame: mio_main_tl_mbx4__sram
        index: -1
      }
      {
        name: core_tl_d
        struct: tl
        package: tlul_pkg
        type: req_rsp
        act: rsp
        width: 1
        inst_name: mbx4
        default: ""
        end_idx: -1
        top_signame: mbx4_core_tl_d
        index: -1
      }
      {
        name: soc_tl_d
        struct: tl
        package: tlul_pkg
        type: req_rsp
        act: rsp
        width: 1
        inst_name: mbx4
        default: ""
        end_idx: -1
        top_signame: mbx4_soc_tl_d
        index: -1
      }
      {
        name: doe_intr_support
        struct: logic
        type: uni
        act: req
        width: 1
        default: 1'b0
        inst_name: mbx5
        index: -1
      }
      {
        name: doe_intr_en
        struct: logic
        type: uni
        act: req
        width: 1
        default: 1'b0
        inst_name: mbx5
        index: -1
      }
      {
        name: doe_intr
        struct: logic
        type: uni
        act: req
        width: 1
        default: 1'b0
        inst_name: mbx5
        index: -1
      }
      {
        name: doe_async_msg_support
        struct: logic
        type: uni
        act: req
        width: 1
        default: 1'b0
        inst_name: mbx5
        index: -1
      }
      {
        name: racl_policies
        desc:
          '''
          Incoming RACL policy vector from a racl_ctrl instance.
          The policy selection vector (parameter) selects the policy for each register.
          '''
        struct: racl_policy_vec
        package: top_racl_pkg
        type: uni
        act: rcv
        width: 1
        inst_name: mbx5
        default: ""
        top_signame: racl_ctrl_mio_racl_policies
        index: -1
      }
      {
        name: racl_error
        desc: RACL error log information of this module.
        struct: racl_error_log
        package: top_racl_pkg
        type: uni
        act: req
        width: 1
        inst_name: mbx5
        default: ""
        top_signame: racl_ctrl_mio_racl_error
        index: 13
      }
      {
        name: sram_tl_h
        struct: tl
        package: tlul_pkg
        type: req_rsp
        act: req
        width: 1
        inst_name: mbx5
        default: ""
        top_signame: mio_main_tl_mbx5__sram
        index: -1
      }
      {
        name: core_tl_d
        struct: tl
        package: tlul_pkg
        type: req_rsp
        act: rsp
        width: 1
        inst_name: mbx5
        default: ""
        end_idx: -1
        top_signame: mbx5_core_tl_d
        index: -1
      }
      {
        name: soc_tl_d
        struct: tl
        package: tlul_pkg
        type: req_rsp
        act: rsp
        width: 1
        inst_name: mbx5
        default: ""
        end_idx: -1
        top_signame: mbx5_soc_tl_d
        index: -1
      }
      {
        name: doe_intr_support
        struct: logic
        type: uni
        act: req
        width: 1
        default: 1'b0
        inst_name: mbx_pcie0
        index: -1
      }
      {
        name: doe_intr_en
        struct: logic
        type: uni
        act: req
        width: 1
        default: 1'b0
        inst_name: mbx_pcie0
        index: -1
      }
      {
        name: doe_intr
        struct: logic
        type: uni
        act: req
        width: 1
        default: 1'b0
        inst_name: mbx_pcie0
        index: -1
      }
      {
        name: doe_async_msg_support
        struct: logic
        type: uni
        act: req
        width: 1
        default: 1'b0
        inst_name: mbx_pcie0
        index: -1
      }
      {
        name: racl_policies
        desc:
          '''
          Incoming RACL policy vector from a racl_ctrl instance.
          The policy selection vector (parameter) selects the policy for each register.
          '''
        struct: racl_policy_vec
        package: top_racl_pkg
        type: uni
        act: rcv
        width: 1
        inst_name: mbx_pcie0
        default: ""
        top_signame: racl_ctrl_mio_racl_policies
        index: -1
      }
      {
        name: racl_error
        desc: RACL error log information of this module.
        struct: racl_error_log
        package: top_racl_pkg
        type: uni
        act: req
        width: 1
        inst_name: mbx_pcie0
        default: ""
        top_signame: racl_ctrl_mio_racl_error
        index: 14
      }
      {
        name: sram_tl_h
        struct: tl
        package: tlul_pkg
        type: req_rsp
        act: req
        width: 1
        inst_name: mbx_pcie0
        default: ""
        top_signame: mio_main_tl_mbx_pcie0__sram
        index: -1
      }
      {
        name: core_tl_d
        struct: tl
        package: tlul_pkg
        type: req_rsp
        act: rsp
        width: 1
        inst_name: mbx_pcie0
        default: ""
        end_idx: -1
        top_signame: mbx_pcie0_core_tl_d
        index: -1
      }
      {
        name: soc_tl_d
        struct: tl
        package: tlul_pkg
        type: req_rsp
        act: rsp
        width: 1
        inst_name: mbx_pcie0
        default: ""
        end_idx: -1
        top_signame: mbx_pcie0_soc_tl_d
        index: -1
      }
      {
        name: racl_policies
        desc: Policy vector distributed to the subscribing RACL IPs.
        struct: racl_policy_vec
        package: top_racl_pkg
        type: uni
        act: req
        width: 1
        inst_name: racl_ctrl_mio
        default: ""
        end_idx: -1
        top_type: broadcast
        top_signame: racl_ctrl_mio_racl_policies
        index: -1
        external: true
        conn_type: true
      }
      {
        name: racl_error
        desc:
          '''
          Error log information from all IPs.
          Only one IP can raise an error at a time.
          '''
        struct: racl_error_log
        package: top_racl_pkg
        type: uni
        act: rcv
        width:
        {
          name: NumSubscribingIps
          desc: Number of subscribing RACL IPs
          param_type: int
          unpacked_dimensions: null
          default: 17
          local: true
          expose: true
          name_top: RaclCtrlMioNumSubscribingIps
        }
        inst_name: racl_ctrl_mio
        default: ""
        end_idx: -1
        top_type: one-to-N
        top_signame: racl_ctrl_mio_racl_error
        index: -1
      }
      {
        name: racl_error_external
        desc:
          '''
          Error log information from all external IPs.
          Only one IP can raise an error at a time.
          '''
        struct: racl_error_log
        package: top_racl_pkg
        type: uni
        act: rcv
        width:
        {
          name: NumExternalSubscribingIps
          desc: Number of external subscribing RACL IPs
          param_type: int
          unpacked_dimensions: null
          default: 1
          local: false
          expose: true
          name_top: RaclCtrlMioNumExternalSubscribingIps
        }
        inst_name: racl_ctrl_mio
        default: ""
        external: true
        top_signame: racl_error
        conn_type: false
        index: -1
      }
      {
        name: tl
        struct: tl
        package: tlul_pkg
        type: req_rsp
        act: rsp
        width: 1
        inst_name: racl_ctrl_mio
        default: ""
        end_idx: -1
        top_signame: racl_ctrl_mio_tl
        index: -1
      }
      {
        name: range_check_overwrite
        desc: Overwrites all ranges and let all requests pass through.
        struct: mubi8
        package: prim_mubi_pkg
        type: uni
        act: rcv
        width: 1
        inst_name: ac_range_check_mio
        default: ""
        external: true
        top_signame: ac_range_check_overwrite
        conn_type: false
        index: -1
      }
      {
        name: ctn_tl_h2d
        desc: TL-UL input port (request part), synchronous
        struct: tl_h2d
        package: tlul_pkg
        type: uni
        act: rcv
        width: 1
        inst_name: ac_range_check_mio
        default: ""
        top_signame: mio_soc_proxy_muxed_tl_h2d
        index: -1
      }
      {
        name: ctn_tl_d2h
        desc: TL-UL input port (response part), synchronous
        struct: tl_d2h
        package: tlul_pkg
        type: uni
        act: req
        width: 1
        inst_name: ac_range_check_mio
        default: ""
        top_signame: mio_soc_proxy_muxed_tl_d2h
        index: -1
      }
      {
        name: ctn_filtered_tl_h2d
        desc: Filtered TL-UL output port (request part), synchronous
        struct: tl_h2d
        package: tlul_pkg
        type: uni
        act: req
        width: 1
        inst_name: ac_range_check_mio
        default: ""
        end_idx: -1
        top_type: broadcast
        top_signame: ac_range_check_mio_ctn_filtered_tl_h2d
        index: -1
      }
      {
        name: ctn_filtered_tl_d2h
        desc: Filtered TL-UL output port (response part), synchronous
        struct: tl_d2h
        package: tlul_pkg
        type: uni
        act: rcv
        width: 1
        inst_name: ac_range_check_mio
        default: ""
        end_idx: -1
        top_type: broadcast
        top_signame: ac_range_check_mio_ctn_filtered_tl_d2h
        index: -1
      }
      {
        name: racl_policies
        desc:
          '''
          Incoming RACL policy vector from a racl_ctrl instance.
          The policy selection vector (parameter) selects the policy for each register.
          '''
        struct: racl_policy_vec
        package: top_racl_pkg
        type: uni
        act: rcv
        width: 1
        inst_name: ac_range_check_mio
        default: ""
        top_signame: racl_ctrl_mio_racl_policies
        index: -1
      }
      {
        name: racl_error
        desc: RACL error log information of this module.
        struct: racl_error_log
        package: top_racl_pkg
        type: uni
        act: req
        width: 1
        inst_name: ac_range_check_mio
        default: ""
        top_signame: racl_ctrl_mio_racl_error
        index: 15
      }
      {
        name: tl
        struct: tl
        package: tlul_pkg
        type: req_rsp
        act: rsp
        width: 1
        inst_name: ac_range_check_mio
        default: ""
        end_idx: -1
        top_signame: ac_range_check_mio_tl
        index: -1
      }
      {
        name: rst_cpu_n
        struct: logic
        type: uni
        act: req
        width: 1
        inst_name: rv_core_ibex_mio
        index: -1
      }
      {
        name: ram_cfg_icache_tag
        struct: ram_1p_cfg
        package: prim_ram_1p_pkg
        type: uni
        act: rcv
        width: 1
        inst_name: rv_core_ibex_mio
        index: -1
      }
      {
        name: ram_cfg_rsp_icache_tag
        struct: ram_1p_cfg_rsp
        package: prim_ram_1p_pkg
        type: uni
        act: req
        width:
        {
          name: ICacheNWays
          desc: Number of instruction cache ways
          param_type: int unsigned
          unpacked_dimensions: null
          default: 2
          local: false
          expose: true
          name_top: RvCoreIbexMioICacheNWays
        }
        inst_name: rv_core_ibex_mio
        index: -1
      }
      {
        name: ram_cfg_icache_data
        struct: ram_1p_cfg
        package: prim_ram_1p_pkg
        type: uni
        act: rcv
        width: 1
        inst_name: rv_core_ibex_mio
        index: -1
      }
      {
        name: ram_cfg_rsp_icache_data
        struct: ram_1p_cfg_rsp
        package: prim_ram_1p_pkg
        type: uni
        act: req
        width:
        {
          name: ICacheNWays
          desc: Number of instruction cache ways
          param_type: int unsigned
          unpacked_dimensions: null
          default: 2
          local: false
          expose: true
          name_top: RvCoreIbexMioICacheNWays
        }
        inst_name: rv_core_ibex_mio
        index: -1
      }
      {
        name: hart_id
        struct: logic
        type: uni
        act: rcv
        width: 32
        inst_name: rv_core_ibex_mio
        default: ""
        package: ""
        top_signame: rv_core_ibex_mio_hart_id
        index: -1
      }
      {
        name: boot_addr
        struct: logic
        type: uni
        act: rcv
        width: 32
        inst_name: rv_core_ibex_mio
        default: ""
        package: ""
        external: true
        top_signame: rv_boot_addr
        conn_type: false
        index: -1
      }
      {
        name: irq_software
        struct: logic
        type: uni
        act: rcv
        width: 1
        inst_name: rv_core_ibex_mio
        default: ""
        package: ""
        top_signame: rv_plic_mio_msip
        index: -1
      }
      {
        name: irq_timer
        struct: logic
        type: uni
        act: rcv
        width: 1
        inst_name: rv_core_ibex_mio
        default: ""
        package: ""
        top_signame: rv_core_ibex_mio_irq_timer
        index: -1
      }
      {
        name: irq_external
        struct: logic
        type: uni
        act: rcv
        width: 1
        inst_name: rv_core_ibex_mio
        default: ""
        package: ""
        top_signame: rv_plic_mio_irq
        index: -1
      }
      {
        name: esc_tx
        struct: esc_tx
        package: prim_esc_pkg
        type: uni
        act: rcv
        width: 1
        inst_name: rv_core_ibex_mio
        default: ""
        external: true
        top_signame: rv_core_esc_tx
        conn_type: false
        index: -1
      }
      {
        name: esc_rx
        struct: esc_rx
        package: prim_esc_pkg
        type: uni
        act: req
        width: 1
        inst_name: rv_core_ibex_mio
        default: ""
        external: true
        top_signame: rv_core_esc_rx
        conn_type: false
        index: -1
      }
      {
        name: debug_req
        struct: logic
        type: uni
        act: rcv
        width: 1
        inst_name: rv_core_ibex_mio
        default: ""
        package: ""
        top_signame: rv_dm_debug_req
        index: -1
      }
      {
        name: crash_dump
        struct: cpu_crash_dump
        package: rv_core_ibex_pkg
        type: uni
        act: req
        width: 1
        inst_name: rv_core_ibex_mio
        index: -1
      }
      {
        name: lc_cpu_en
        struct: lc_tx
        package: lc_ctrl_pkg
        type: uni
        act: rcv
        width: 1
        default: lc_ctrl_pkg::On
        inst_name: rv_core_ibex_mio
        external: true
        top_signame: rv_cpu_en
        conn_type: false
        index: -1
      }
      {
        name: pwrmgr_cpu_en
        struct: lc_tx
        package: lc_ctrl_pkg
        type: uni
        act: rcv
        width: 1
        inst_name: rv_core_ibex_mio
        default: ""
        external: true
        top_signame: rv_pwrmgr_cpu_en
        conn_type: false
        index: -1
      }
      {
        name: pwrmgr
        struct: cpu_pwrmgr
        package: rv_core_ibex_pkg
        type: uni
        act: req
        width: 1
        inst_name: rv_core_ibex_mio
        index: -1
      }
      {
        name: nmi_wdog
        struct: logic
        type: uni
        act: rcv
        width: 1
        inst_name: rv_core_ibex_mio
        default: ""
        package: ""
        top_signame: aon_timer_aon_nmi_wdog_timer_bark
        index: -1
      }
      {
        name: edn
        struct: edn
        package: edn_pkg
        type: req_rsp
        act: req
        width: 1
        inst_name: rv_core_ibex_mio
        index: -1
      }
      {
        name: icache_otp_key
        struct: sram_otp_key
        package: otp_ctrl_pkg
        type: req_rsp
        act: req
        width: 1
        inst_name: rv_core_ibex_mio
        index: -1
      }
      {
        name: fpga_info
        struct: logic
        type: uni
        act: rcv
        width: 32
        inst_name: rv_core_ibex_mio
        default: ""
        package: ""
        external: true
        top_signame: fpga_info
        conn_type: false
        index: -1
      }
      {
        name: racl_policies
        desc:
          '''
          Incoming RACL policy vector from a racl_ctrl instance.
          The policy selection vector (parameter) selects the policy for each register.
          '''
        struct: racl_policy_vec
        package: top_racl_pkg
        type: uni
        act: rcv
        width: 1
        inst_name: rv_core_ibex_mio
        default: ""
        top_signame: racl_ctrl_mio_racl_policies
        index: -1
      }
      {
        name: racl_error
        desc: RACL error log information of this module.
        struct: racl_error_log
        package: top_racl_pkg
        type: uni
        act: req
        width: 1
        inst_name: rv_core_ibex_mio
        default: ""
        top_signame: racl_ctrl_mio_racl_error
        index: 16
      }
      {
        name: corei_tl_h
        struct: tl
        package: tlul_pkg
        type: req_rsp
        act: req
        width: 1
        inst_name: rv_core_ibex_mio
        default: ""
        top_signame: mio_main_tl_rv_core_ibex_mio__corei
        index: -1
      }
      {
        name: cored_tl_h
        struct: tl
        package: tlul_pkg
        type: req_rsp
        act: req
        width: 1
        inst_name: rv_core_ibex_mio
        default: ""
        top_signame: mio_main_tl_rv_core_ibex_mio__cored
        index: -1
      }
      {
        name: cfg_tl_d
        struct: tl
        package: tlul_pkg
        type: req_rsp
        act: rsp
        width: 1
        inst_name: rv_core_ibex_mio
        default: ""
        end_idx: -1
        top_signame: rv_core_ibex_mio_cfg_tl_d
        index: -1
      }
      {
        name: tl_rv_core_ibex_mio__corei
        struct: tl
        package: tlul_pkg
        type: req_rsp
        act: rsp
        inst_name: mio_main
        width: 1
        default: ""
        end_idx: -1
        top_signame: mio_main_tl_rv_core_ibex_mio__corei
        index: -1
      }
      {
        name: tl_rv_core_ibex_mio__cored
        struct: tl
        package: tlul_pkg
        type: req_rsp
        act: rsp
        inst_name: mio_main
        width: 1
        default: ""
        end_idx: -1
        top_signame: mio_main_tl_rv_core_ibex_mio__cored
        index: -1
      }
      {
        name: tl_rv_dm__sba
        struct: tl
        package: tlul_pkg
        type: req_rsp
        act: rsp
        inst_name: mio_main
        width: 1
        default: ""
        end_idx: -1
        top_signame: mio_main_tl_rv_dm__sba
        index: -1
      }
      {
        name: tl_dma__host
        struct: tl
        package: tlul_pkg
        type: req_rsp
        act: rsp
        inst_name: mio_main
        width: 1
        default: ""
        end_idx: -1
        top_signame: mio_main_tl_dma__host
        index: -1
      }
      {
        name: tl_mbx0__sram
        struct: tl
        package: tlul_pkg
        type: req_rsp
        act: rsp
        inst_name: mio_main
        width: 1
        default: ""
        end_idx: -1
        top_signame: mio_main_tl_mbx0__sram
        index: -1
      }
      {
        name: tl_mbx1__sram
        struct: tl
        package: tlul_pkg
        type: req_rsp
        act: rsp
        inst_name: mio_main
        width: 1
        default: ""
        end_idx: -1
        top_signame: mio_main_tl_mbx1__sram
        index: -1
      }
      {
        name: tl_mbx2__sram
        struct: tl
        package: tlul_pkg
        type: req_rsp
        act: rsp
        inst_name: mio_main
        width: 1
        default: ""
        end_idx: -1
        top_signame: mio_main_tl_mbx2__sram
        index: -1
      }
      {
        name: tl_mbx3__sram
        struct: tl
        package: tlul_pkg
        type: req_rsp
        act: rsp
        inst_name: mio_main
        width: 1
        default: ""
        end_idx: -1
        top_signame: mio_main_tl_mbx3__sram
        index: -1
      }
      {
        name: tl_mbx4__sram
        struct: tl
        package: tlul_pkg
        type: req_rsp
        act: rsp
        inst_name: mio_main
        width: 1
        default: ""
        end_idx: -1
        top_signame: mio_main_tl_mbx4__sram
        index: -1
      }
      {
        name: tl_mbx5__sram
        struct: tl
        package: tlul_pkg
        type: req_rsp
        act: rsp
        inst_name: mio_main
        width: 1
        default: ""
        end_idx: -1
        top_signame: mio_main_tl_mbx5__sram
        index: -1
      }
      {
        name: tl_mbx_pcie0__sram
        struct: tl
        package: tlul_pkg
        type: req_rsp
        act: rsp
        inst_name: mio_main
        width: 1
        default: ""
        end_idx: -1
        top_signame: mio_main_tl_mbx_pcie0__sram
        index: -1
      }
      {
        name: tl_rv_dm__regs
        struct: tl
        package: tlul_pkg
        type: req_rsp
        act: req
        inst_name: mio_main
        width: 1
        default: ""
        top_signame: rv_dm_regs_tl_d
        index: -1
      }
      {
        name: tl_rv_dm__mem
        struct: tl
        package: tlul_pkg
        type: req_rsp
        act: req
        inst_name: mio_main
        width: 1
        default: ""
        top_signame: rv_dm_mem_tl_d
        index: -1
      }
      {
        name: tl_mio_peri
        struct: tl
        package: tlul_pkg
        type: req_rsp
        act: req
        inst_name: mio_main
        width: 1
        default: ""
        end_idx: -1
        top_signame: mio_main_tl_mio_peri
        index: -1
      }
      {
        name: tl_mio_soc_proxy__ctn
        struct: tl
        package: tlul_pkg
        type: req_rsp
        act: req
        inst_name: mio_main
        width: 1
        default: ""
        top_signame: mio_soc_proxy_ctn_tl
        index: -1
      }
      {
        name: tl_rv_plic_mio
        struct: tl
        package: tlul_pkg
        type: req_rsp
        act: req
        inst_name: mio_main
        width: 1
        default: ""
        top_signame: rv_plic_mio_tl
        index: -1
      }
      {
        name: tl_rv_core_ibex_mio__cfg
        struct: tl
        package: tlul_pkg
        type: req_rsp
        act: req
        inst_name: mio_main
        width: 1
        default: ""
        top_signame: rv_core_ibex_mio_cfg_tl_d
        index: -1
      }
      {
        name: tl_sram_ctrl_main__regs
        struct: tl
        package: tlul_pkg
        type: req_rsp
        act: req
        inst_name: mio_main
        width: 1
        default: ""
        top_signame: sram_ctrl_main_regs_tl
        index: -1
      }
      {
        name: tl_sram_ctrl_main__ram
        struct: tl
        package: tlul_pkg
        type: req_rsp
        act: req
        inst_name: mio_main
        width: 1
        default: ""
        top_signame: sram_ctrl_main_ram_tl
        index: -1
      }
      {
        name: tl_sram_ctrl_mbox__regs
        struct: tl
        package: tlul_pkg
        type: req_rsp
        act: req
        inst_name: mio_main
        width: 1
        default: ""
        top_signame: sram_ctrl_mbox_regs_tl
        index: -1
      }
      {
        name: tl_sram_ctrl_mbox__ram
        struct: tl
        package: tlul_pkg
        type: req_rsp
        act: req
        inst_name: mio_main
        width: 1
        default: ""
        top_signame: sram_ctrl_mbox_ram_tl
        index: -1
      }
      {
        name: tl_dma
        struct: tl
        package: tlul_pkg
        type: req_rsp
        act: req
        inst_name: mio_main
        width: 1
        default: ""
        top_signame: dma_tl_d
        index: -1
      }
      {
        name: tl_mbx0__core
        struct: tl
        package: tlul_pkg
        type: req_rsp
        act: req
        inst_name: mio_main
        width: 1
        default: ""
        top_signame: mbx0_core_tl_d
        index: -1
      }
      {
        name: tl_mbx1__core
        struct: tl
        package: tlul_pkg
        type: req_rsp
        act: req
        inst_name: mio_main
        width: 1
        default: ""
        top_signame: mbx1_core_tl_d
        index: -1
      }
      {
        name: tl_mbx2__core
        struct: tl
        package: tlul_pkg
        type: req_rsp
        act: req
        inst_name: mio_main
        width: 1
        default: ""
        top_signame: mbx2_core_tl_d
        index: -1
      }
      {
        name: tl_mbx3__core
        struct: tl
        package: tlul_pkg
        type: req_rsp
        act: req
        inst_name: mio_main
        width: 1
        default: ""
        top_signame: mbx3_core_tl_d
        index: -1
      }
      {
        name: tl_mbx4__core
        struct: tl
        package: tlul_pkg
        type: req_rsp
        act: req
        inst_name: mio_main
        width: 1
        default: ""
        top_signame: mbx4_core_tl_d
        index: -1
      }
      {
        name: tl_mbx5__core
        struct: tl
        package: tlul_pkg
        type: req_rsp
        act: req
        inst_name: mio_main
        width: 1
        default: ""
        top_signame: mbx5_core_tl_d
        index: -1
      }
      {
        name: tl_mbx_pcie0__core
        struct: tl
        package: tlul_pkg
        type: req_rsp
        act: req
        inst_name: mio_main
        width: 1
        default: ""
        top_signame: mbx_pcie0_core_tl_d
        index: -1
      }
      {
        name: tl_mio_main
        struct: tl
        package: tlul_pkg
        type: req_rsp
        act: rsp
        inst_name: mio_peri
        width: 1
        default: ""
        top_signame: mio_main_tl_mio_peri
        index: -1
      }
      {
        name: tl_rv_timer
        struct: tl
        package: tlul_pkg
        type: req_rsp
        act: req
        inst_name: mio_peri
        width: 1
        default: ""
        top_signame: rv_timer_tl
        index: -1
      }
      {
        name: tl_sram_ctrl_ret_aon__regs
        struct: tl
        package: tlul_pkg
        type: req_rsp
        act: req
        inst_name: mio_peri
        width: 1
        default: ""
        top_signame: sram_ctrl_ret_aon_regs_tl
        index: -1
      }
      {
        name: tl_sram_ctrl_ret_aon__ram
        struct: tl
        package: tlul_pkg
        type: req_rsp
        act: req
        inst_name: mio_peri
        width: 1
        default: ""
        top_signame: sram_ctrl_ret_aon_ram_tl
        index: -1
      }
      {
        name: tl_aon_timer_aon
        struct: tl
        package: tlul_pkg
        type: req_rsp
        act: req
        inst_name: mio_peri
        width: 1
        default: ""
        top_signame: aon_timer_aon_tl
        index: -1
      }
      {
        name: tl_mio_mbx
        struct: tl
        package: tlul_pkg
        type: req_rsp
        act: rsp
        inst_name: mio_mbx
        width: 1
        default: ""
        external: true
        top_signame: mbx_tl
        conn_type: false
        index: -1
      }
      {
        name: tl_mbx0__soc
        struct: tl
        package: tlul_pkg
        type: req_rsp
        act: req
        inst_name: mio_mbx
        width: 1
        default: ""
        top_signame: mbx0_soc_tl_d
        index: -1
      }
      {
        name: tl_mbx1__soc
        struct: tl
        package: tlul_pkg
        type: req_rsp
        act: req
        inst_name: mio_mbx
        width: 1
        default: ""
        top_signame: mbx1_soc_tl_d
        index: -1
      }
      {
        name: tl_mbx2__soc
        struct: tl
        package: tlul_pkg
        type: req_rsp
        act: req
        inst_name: mio_mbx
        width: 1
        default: ""
        top_signame: mbx2_soc_tl_d
        index: -1
      }
      {
        name: tl_mbx3__soc
        struct: tl
        package: tlul_pkg
        type: req_rsp
        act: req
        inst_name: mio_mbx
        width: 1
        default: ""
        top_signame: mbx3_soc_tl_d
        index: -1
      }
      {
        name: tl_mbx4__soc
        struct: tl
        package: tlul_pkg
        type: req_rsp
        act: req
        inst_name: mio_mbx
        width: 1
        default: ""
        top_signame: mbx4_soc_tl_d
        index: -1
      }
      {
        name: tl_mbx5__soc
        struct: tl
        package: tlul_pkg
        type: req_rsp
        act: req
        inst_name: mio_mbx
        width: 1
        default: ""
        top_signame: mbx5_soc_tl_d
        index: -1
      }
      {
        name: tl_mbx_pcie0__soc
        struct: tl
        package: tlul_pkg
        type: req_rsp
        act: req
        inst_name: mio_mbx
        width: 1
        default: ""
        top_signame: mbx_pcie0_soc_tl_d
        index: -1
      }
      {
        name: tl_racl_ctrl_mio
        struct: tl
        package: tlul_pkg
        type: req_rsp
        act: req
        inst_name: mio_mbx
        width: 1
        default: ""
        top_signame: racl_ctrl_mio_tl
        index: -1
      }
      {
        name: tl_ac_range_check_mio
        struct: tl
        package: tlul_pkg
        type: req_rsp
        act: req
        inst_name: mio_mbx
        width: 1
        default: ""
        top_signame: ac_range_check_mio_tl
        index: -1
      }
    ]
    external:
    [
      {
        package: dma_pkg
        struct: sys_req
        signame: dma_sys_req_o
        width: 1
        type: req_rsp
        default: ""
        direction: out
        conn_type: false
        index: -1
        netname: dma_sys_req
      }
      {
        package: dma_pkg
        struct: sys_rsp
        signame: dma_sys_rsp_i
        width: 1
        type: req_rsp
        default: ""
        direction: in
        conn_type: false
        index: -1
        netname: dma_sys_rsp
      }
      {
        package: tlul_pkg
        struct: tl_h2d
        signame: mbx_tl_req_i
        width: 1
        type: req_rsp
        default: ""
        direction: in
        conn_type: false
        index: -1
        netname: mbx_tl_h2d
      }
      {
        package: tlul_pkg
        struct: tl_d2h
        signame: mbx_tl_rsp_o
        width: 1
        type: req_rsp
        default: ""
        direction: out
        conn_type: false
        index: -1
        netname: mbx_tl_d2h
      }
      {
        package: rv_dm_pkg
        struct: next_dm_addr
        signame: rv_dm_next_dm_addr_i
        width: 1
        type: uni
        default: "'0"
        direction: in
        conn_type: false
        index: -1
        netname: rv_dm_next_dm_addr
      }
      {
        package: tlul_pkg
        struct: tl_h2d
        signame: rv_dm_dbg_req_i
        width: 1
        type: req_rsp
        default: ""
        direction: in
        conn_type: false
        index: -1
        netname: rv_dm_dbg_h2d
      }
      {
        package: tlul_pkg
        struct: tl_d2h
        signame: rv_dm_dbg_rsp_o
        width: 1
        type: req_rsp
        default: ""
        direction: out
        conn_type: false
        index: -1
        netname: rv_dm_dbg_d2h
      }
      {
        package: ""
        struct: logic
        signame: fpga_info_i
        width: 32
        type: uni
        default: ""
        direction: in
        conn_type: false
        index: -1
        netname: fpga_info
      }
      {
        package: ""
        struct: logic
        signame: rv_boot_addr_i
        width: 32
        type: uni
        default: ""
        direction: in
        conn_type: false
        index: -1
        netname: rv_boot_addr
      }
      {
        package: lc_ctrl_pkg
        struct: lc_tx
        signame: rv_pwrmgr_cpu_en_i
        width: 1
        type: uni
        default: ""
        direction: in
        conn_type: false
        index: -1
        netname: rv_pwrmgr_cpu_en
      }
      {
        package: lc_ctrl_pkg
        struct: lc_tx
        signame: rv_cpu_en_i
        width: 1
        type: uni
        default: lc_ctrl_pkg::On
        direction: in
        conn_type: false
        index: -1
        netname: rv_cpu_en
      }
      {
        package: prim_esc_pkg
        struct: esc_rx
        signame: rv_core_esc_rx_o
        width: 1
        type: uni
        default: ""
        direction: out
        conn_type: false
        index: -1
        netname: rv_core_esc_rx
      }
      {
        package: prim_esc_pkg
        struct: esc_tx
        signame: rv_core_esc_tx_i
        width: 1
        type: uni
        default: ""
        direction: in
        conn_type: false
        index: -1
        netname: rv_core_esc_tx
      }
      {
        package: ""
        struct: logic
        signame: soc_lsio_trigger_i
        width: 8
        type: uni
        default: ""
        direction: in
        conn_type: false
        index: -1
        netname: soc_lsio_trigger
      }
      {
        package: lc_ctrl_pkg
        struct: lc_tx
        signame: lc_hw_debug_en_ext_i
        width: 1
        type: uni
        default: lc_ctrl_pkg::Off
        direction: in
        conn_type: false
        index: -1
        netname: lc_hw_debug_en_ext
      }
      {
        package: lc_ctrl_pkg
        struct: lc_tx
        signame: lc_escalate_en_ext_i
        width: 1
        type: uni
        default: lc_ctrl_pkg::Off
        direction: in
        conn_type: false
        index: -1
        netname: lc_escalate_en_ext
      }
      {
        package: tlul_pkg
        struct: tl_h2d
        signame: ctn_tl_h2d_o
        width: 1
        type: uni
        default: ""
        direction: out
        conn_type: false
        index: -1
        netname: ctn_tl_h2d
      }
      {
        package: tlul_pkg
        struct: tl_d2h
        signame: ctn_tl_d2h_i
        width: 1
        type: uni
        default: ""
        direction: in
        conn_type: false
        index: -1
        netname: ctn_tl_d2h
      }
      {
        package: ""
        struct: logic
        signame: integrator_id_i
        width: 4
        type: uni
        default: ""
        direction: in
        conn_type: false
        index: -1
        netname: integrator_id
      }
      {
        package: lc_ctrl_pkg
        struct: lc_tx
        signame: lc_check_byp_en_i
        width: 1
        type: uni
        default: lc_ctrl_pkg::Off
        direction: in
        conn_type: false
        index: -1
        netname: lc_check_byp_en
      }
      {
        package: ""
        struct: logic
        signame: rv_dm_strap_en_i
        width: 1
        type: uni
        default: 1'b0
        direction: in
        conn_type: false
        index: -1
        netname: rv_dm_strap_en
      }
      {
        package: ""
        struct: logic
        signame: rv_dm_strap_en_override_i
        width: 1
        type: uni
        default: 1'b0
        direction: in
        conn_type: false
        index: -1
        netname: rv_dm_strap_en_override
      }
      {
        package: prim_ram_1p_pkg
        struct: ram_1p_cfg
        signame: sram_ctrl_ret_aon_ram_1p_cfg_i
        width:
        {
          name: NumRamInst
          desc: Number of internal RAM instances. Must be the same as ceil(MemSizeRam / InstSize) .
          param_type: int
          unpacked_dimensions: null
          default: 1
          local: false
          expose: true
          name_top: SramCtrlRetAonNumRamInst
        }
        type: uni
        default: "'0"
        direction: in
        conn_type: false
        index: -1
        netname: sram_ctrl_ret_aon_ram_1p_cfg
      }
      {
        package: prim_ram_1p_pkg
        struct: ram_1p_cfg_rsp
        signame: sram_ctrl_ret_aon_ram_1p_cfg_rsp_o
        width:
        {
          name: NumRamInst
          desc: Number of internal RAM instances. Must be the same as ceil(MemSizeRam / InstSize) .
          param_type: int
          unpacked_dimensions: null
          default: 1
          local: false
          expose: true
          name_top: SramCtrlRetAonNumRamInst
        }
        type: uni
        default: "'0"
        direction: out
        conn_type: false
        index: -1
        netname: sram_ctrl_ret_aon_ram_1p_cfg_rsp
      }
      {
        package: prim_ram_1p_pkg
        struct: ram_1p_cfg
        signame: sram_ctrl_main_ram_1p_cfg_i
        width:
        {
          name: NumRamInst
          desc: Number of internal RAM instances. Must be the same as ceil(MemSizeRam / InstSize) .
          param_type: int
          unpacked_dimensions: null
          default: 1
          local: false
          expose: true
          name_top: SramCtrlMainNumRamInst
        }
        type: uni
        default: "'0"
        direction: in
        conn_type: false
        index: -1
        netname: sram_ctrl_main_ram_1p_cfg
      }
      {
        package: prim_ram_1p_pkg
        struct: ram_1p_cfg_rsp
        signame: sram_ctrl_main_ram_1p_cfg_rsp_o
        width:
        {
          name: NumRamInst
          desc: Number of internal RAM instances. Must be the same as ceil(MemSizeRam / InstSize) .
          param_type: int
          unpacked_dimensions: null
          default: 1
          local: false
          expose: true
          name_top: SramCtrlMainNumRamInst
        }
        type: uni
        default: "'0"
        direction: out
        conn_type: false
        index: -1
        netname: sram_ctrl_main_ram_1p_cfg_rsp
      }
      {
        package: prim_ram_1p_pkg
        struct: ram_1p_cfg
        signame: sram_ctrl_mbox_ram_1p_cfg_i
        width:
        {
          name: NumRamInst
          desc: Number of internal RAM instances. Must be the same as ceil(MemSizeRam / InstSize) .
          param_type: int
          unpacked_dimensions: null
          default: 1
          local: false
          expose: true
          name_top: SramCtrlMboxNumRamInst
        }
        type: uni
        default: "'0"
        direction: in
        conn_type: false
        index: -1
        netname: sram_ctrl_mbox_ram_1p_cfg
      }
      {
        package: prim_ram_1p_pkg
        struct: ram_1p_cfg_rsp
        signame: sram_ctrl_mbox_ram_1p_cfg_rsp_o
        width:
        {
          name: NumRamInst
          desc: Number of internal RAM instances. Must be the same as ceil(MemSizeRam / InstSize) .
          param_type: int
          unpacked_dimensions: null
          default: 1
          local: false
          expose: true
          name_top: SramCtrlMboxNumRamInst
        }
        type: uni
        default: "'0"
        direction: out
        conn_type: false
        index: -1
        netname: sram_ctrl_mbox_ram_1p_cfg_rsp
      }
      {
        package: top_racl_pkg
        struct: racl_policy_vec
        signame: racl_policies_o
        width: 1
        type: uni
        default: ""
        direction: out
        conn_type: true
        index: -1
        netname: racl_ctrl_mio_racl_policies
      }
      {
        package: top_racl_pkg
        struct: racl_error_log
        signame: racl_error_i
        width:
        {
          name: NumExternalSubscribingIps
          desc: Number of external subscribing RACL IPs
          param_type: int
          unpacked_dimensions: null
          default: 1
          local: false
          expose: true
          name_top: RaclCtrlMioNumExternalSubscribingIps
        }
        type: uni
        default: ""
        direction: in
        conn_type: false
        index: -1
        netname: racl_error
      }
      {
        package: prim_mubi_pkg
        struct: mubi8
        signame: ac_range_check_overwrite_i
        width: 1
        type: uni
        default: ""
        direction: in
        conn_type: false
        index: -1
        netname: ac_range_check_overwrite
      }
      {
        package: ""
        struct: logic
        signame: aon_timer_rst_req_o
        width: 1
        type: uni
        default: 1'b0
        direction: out
        conn_type: false
        index: -1
        netname: aon_timer_rst_req
      }
    ]
    definitions:
    [
      {
        package: ""
        struct: logic
        signame: aon_timer_aon_nmi_wdog_timer_bark
        width: 1
        type: uni
        end_idx: -1
        act: req
        suffix: ""
        default: 1'b0
      }
      {
        package: dma_pkg
        struct: lsio_trigger
        signame: dma_lsio_trigger
        width: 1
        type: uni
        end_idx: -1
        act: rcv
        suffix: ""
        default: dma_pkg::LSIO_TRIGGER_DEFAULT
      }
      {
        package: ""
        struct: logic
        signame: rv_plic_mio_msip
        width: 1
        type: uni
        end_idx: -1
        act: req
        suffix: ""
        default: "'0"
      }
      {
        package: ""
        struct: logic
        signame: rv_plic_mio_irq
        width: 1
        type: uni
        end_idx: -1
        act: req
        suffix: ""
        default: "'0"
      }
      {
        package: ""
        struct: logic [rv_dm_reg_pkg::NrHarts-1:0]
        signame: rv_dm_debug_req
        width: 1
        type: uni
        end_idx: -1
        act: req
        suffix: ""
        default: "'0"
      }
      {
        package: lc_ctrl_pkg
        struct: lc_tx
        signame: mio_soc_proxy_lc_hw_debug_en
        width: 1
        type: uni
        end_idx: -1
        act: req
        suffix: ""
        default: lc_ctrl_pkg::Off
      }
      {
        package: lc_ctrl_pkg
        struct: lc_tx
        signame: mio_soc_proxy_lc_escalate_en
        width: 1
        type: uni
        end_idx: -1
        act: req
        suffix: ""
        default: lc_ctrl_pkg::Off
      }
      {
        package: prim_mubi_pkg
        struct: mubi8
        signame: sram_ctrl_main_otp_en_sram_ifetch
        width: 1
        type: uni
        end_idx: -1
        act: rcv
        suffix: ""
        default: prim_mubi_pkg::MuBi8False
      }
      {
        package: tlul_pkg
        struct: tl_h2d
        signame: mio_soc_proxy_dma_tl_h2d
        width: 1
        type: uni
        end_idx: -1
        act: rcv
        suffix: ""
        default: tlul_pkg::TL_H2D_DEFAULT
      }
      {
        package: tlul_pkg
        struct: tl_d2h
        signame: mio_soc_proxy_dma_tl_d2h
        width: 1
        type: uni
        end_idx: -1
        act: req
        suffix: ""
        default: tlul_pkg::TL_D2H_DEFAULT
      }
      {
        package: tlul_pkg
        struct: tl_h2d
        signame: mio_soc_proxy_muxed_tl_h2d
        width: 1
        type: uni
        end_idx: -1
        act: req
        suffix: ""
        default: tlul_pkg::TL_H2D_DEFAULT
      }
      {
        package: tlul_pkg
        struct: tl_d2h
        signame: mio_soc_proxy_muxed_tl_d2h
        width: 1
        type: uni
        end_idx: -1
        act: rcv
        suffix: ""
        default: tlul_pkg::TL_D2H_DEFAULT
      }
      {
        package: tlul_pkg
        struct: tl_h2d
        signame: ac_range_check_mio_ctn_filtered_tl_h2d
        width: 1
        type: uni
        end_idx: -1
        act: req
        suffix: ""
        default: tlul_pkg::TL_H2D_DEFAULT
      }
      {
        package: tlul_pkg
        struct: tl_d2h
        signame: ac_range_check_mio_ctn_filtered_tl_d2h
        width: 1
        type: uni
        end_idx: -1
        act: rcv
        suffix: ""
        default: tlul_pkg::TL_D2H_DEFAULT
      }
      {
        package: tlul_pkg
        struct: tl_h2d
        signame: mio_main_tl_rv_core_ibex_mio__corei_req
        width: 1
        type: req_rsp
        end_idx: -1
        act: rsp
        suffix: req
        default: tlul_pkg::TL_H2D_DEFAULT
      }
      {
        package: tlul_pkg
        struct: tl_d2h
        signame: mio_main_tl_rv_core_ibex_mio__corei_rsp
        width: 1
        type: req_rsp
        end_idx: -1
        act: rsp
        suffix: rsp
        default: ""
      }
      {
        package: tlul_pkg
        struct: tl_h2d
        signame: mio_main_tl_rv_core_ibex_mio__cored_req
        width: 1
        type: req_rsp
        end_idx: -1
        act: rsp
        suffix: req
        default: tlul_pkg::TL_H2D_DEFAULT
      }
      {
        package: tlul_pkg
        struct: tl_d2h
        signame: mio_main_tl_rv_core_ibex_mio__cored_rsp
        width: 1
        type: req_rsp
        end_idx: -1
        act: rsp
        suffix: rsp
        default: ""
      }
      {
        package: tlul_pkg
        struct: tl_h2d
        signame: mio_main_tl_rv_dm__sba_req
        width: 1
        type: req_rsp
        end_idx: -1
        act: rsp
        suffix: req
        default: tlul_pkg::TL_H2D_DEFAULT
      }
      {
        package: tlul_pkg
        struct: tl_d2h
        signame: mio_main_tl_rv_dm__sba_rsp
        width: 1
        type: req_rsp
        end_idx: -1
        act: rsp
        suffix: rsp
        default: ""
      }
      {
        package: tlul_pkg
        struct: tl_h2d
        signame: rv_dm_regs_tl_d_req
        width: 1
        type: req_rsp
        end_idx: -1
        act: rsp
        suffix: req
        default: tlul_pkg::TL_H2D_DEFAULT
      }
      {
        package: tlul_pkg
        struct: tl_d2h
        signame: rv_dm_regs_tl_d_rsp
        width: 1
        type: req_rsp
        end_idx: -1
        act: rsp
        suffix: rsp
        default: ""
      }
      {
        package: tlul_pkg
        struct: tl_h2d
        signame: rv_dm_mem_tl_d_req
        width: 1
        type: req_rsp
        end_idx: -1
        act: rsp
        suffix: req
        default: tlul_pkg::TL_H2D_DEFAULT
      }
      {
        package: tlul_pkg
        struct: tl_d2h
        signame: rv_dm_mem_tl_d_rsp
        width: 1
        type: req_rsp
        end_idx: -1
        act: rsp
        suffix: rsp
        default: ""
      }
      {
        package: tlul_pkg
        struct: tl_h2d
        signame: mio_main_tl_mio_peri_req
        width: 1
        type: req_rsp
        end_idx: -1
        act: req
        suffix: req
        default: ""
      }
      {
        package: tlul_pkg
        struct: tl_d2h
        signame: mio_main_tl_mio_peri_rsp
        width: 1
        type: req_rsp
        end_idx: -1
        act: req
        suffix: rsp
        default: tlul_pkg::TL_D2H_DEFAULT
      }
      {
        package: tlul_pkg
        struct: tl_h2d
        signame: mio_soc_proxy_ctn_tl_req
        width: 1
        type: req_rsp
        end_idx: -1
        act: rsp
        suffix: req
        default: tlul_pkg::TL_H2D_DEFAULT
      }
      {
        package: tlul_pkg
        struct: tl_d2h
        signame: mio_soc_proxy_ctn_tl_rsp
        width: 1
        type: req_rsp
        end_idx: -1
        act: rsp
        suffix: rsp
        default: ""
      }
      {
        package: tlul_pkg
        struct: tl_h2d
        signame: rv_plic_mio_tl_req
        width: 1
        type: req_rsp
        end_idx: -1
        act: rsp
        suffix: req
        default: tlul_pkg::TL_H2D_DEFAULT
      }
      {
        package: tlul_pkg
        struct: tl_d2h
        signame: rv_plic_mio_tl_rsp
        width: 1
        type: req_rsp
        end_idx: -1
        act: rsp
        suffix: rsp
        default: ""
      }
      {
        package: tlul_pkg
        struct: tl_h2d
        signame: rv_core_ibex_mio_cfg_tl_d_req
        width: 1
        type: req_rsp
        end_idx: -1
        act: rsp
        suffix: req
        default: tlul_pkg::TL_H2D_DEFAULT
      }
      {
        package: tlul_pkg
        struct: tl_d2h
        signame: rv_core_ibex_mio_cfg_tl_d_rsp
        width: 1
        type: req_rsp
        end_idx: -1
        act: rsp
        suffix: rsp
        default: ""
      }
      {
        package: tlul_pkg
        struct: tl_h2d
        signame: sram_ctrl_main_regs_tl_req
        width: 1
        type: req_rsp
        end_idx: -1
        act: rsp
        suffix: req
        default: tlul_pkg::TL_H2D_DEFAULT
      }
      {
        package: tlul_pkg
        struct: tl_d2h
        signame: sram_ctrl_main_regs_tl_rsp
        width: 1
        type: req_rsp
        end_idx: -1
        act: rsp
        suffix: rsp
        default: ""
      }
      {
        package: tlul_pkg
        struct: tl_h2d
        signame: sram_ctrl_main_ram_tl_req
        width: 1
        type: req_rsp
        end_idx: -1
        act: rsp
        suffix: req
        default: tlul_pkg::TL_H2D_DEFAULT
      }
      {
        package: tlul_pkg
        struct: tl_d2h
        signame: sram_ctrl_main_ram_tl_rsp
        width: 1
        type: req_rsp
        end_idx: -1
        act: rsp
        suffix: rsp
        default: ""
      }
      {
        package: tlul_pkg
        struct: tl_h2d
        signame: sram_ctrl_mbox_regs_tl_req
        width: 1
        type: req_rsp
        end_idx: -1
        act: rsp
        suffix: req
        default: tlul_pkg::TL_H2D_DEFAULT
      }
      {
        package: tlul_pkg
        struct: tl_d2h
        signame: sram_ctrl_mbox_regs_tl_rsp
        width: 1
        type: req_rsp
        end_idx: -1
        act: rsp
        suffix: rsp
        default: ""
      }
      {
        package: tlul_pkg
        struct: tl_h2d
        signame: sram_ctrl_mbox_ram_tl_req
        width: 1
        type: req_rsp
        end_idx: -1
        act: rsp
        suffix: req
        default: tlul_pkg::TL_H2D_DEFAULT
      }
      {
        package: tlul_pkg
        struct: tl_d2h
        signame: sram_ctrl_mbox_ram_tl_rsp
        width: 1
        type: req_rsp
        end_idx: -1
        act: rsp
        suffix: rsp
        default: ""
      }
      {
        package: tlul_pkg
        struct: tl_h2d
        signame: dma_tl_d_req
        width: 1
        type: req_rsp
        end_idx: -1
        act: rsp
        suffix: req
        default: tlul_pkg::TL_H2D_DEFAULT
      }
      {
        package: tlul_pkg
        struct: tl_d2h
        signame: dma_tl_d_rsp
        width: 1
        type: req_rsp
        end_idx: -1
        act: rsp
        suffix: rsp
        default: ""
      }
      {
        package: tlul_pkg
        struct: tl_h2d
        signame: mio_main_tl_dma__host_req
        width: 1
        type: req_rsp
        end_idx: -1
        act: rsp
        suffix: req
        default: tlul_pkg::TL_H2D_DEFAULT
      }
      {
        package: tlul_pkg
        struct: tl_d2h
        signame: mio_main_tl_dma__host_rsp
        width: 1
        type: req_rsp
        end_idx: -1
        act: rsp
        suffix: rsp
        default: ""
      }
      {
        package: tlul_pkg
        struct: tl_h2d
        signame: mbx0_core_tl_d_req
        width: 1
        type: req_rsp
        end_idx: -1
        act: rsp
        suffix: req
        default: tlul_pkg::TL_H2D_DEFAULT
      }
      {
        package: tlul_pkg
        struct: tl_d2h
        signame: mbx0_core_tl_d_rsp
        width: 1
        type: req_rsp
        end_idx: -1
        act: rsp
        suffix: rsp
        default: ""
      }
      {
        package: tlul_pkg
        struct: tl_h2d
        signame: mio_main_tl_mbx0__sram_req
        width: 1
        type: req_rsp
        end_idx: -1
        act: rsp
        suffix: req
        default: tlul_pkg::TL_H2D_DEFAULT
      }
      {
        package: tlul_pkg
        struct: tl_d2h
        signame: mio_main_tl_mbx0__sram_rsp
        width: 1
        type: req_rsp
        end_idx: -1
        act: rsp
        suffix: rsp
        default: ""
      }
      {
        package: tlul_pkg
        struct: tl_h2d
        signame: mbx1_core_tl_d_req
        width: 1
        type: req_rsp
        end_idx: -1
        act: rsp
        suffix: req
        default: tlul_pkg::TL_H2D_DEFAULT
      }
      {
        package: tlul_pkg
        struct: tl_d2h
        signame: mbx1_core_tl_d_rsp
        width: 1
        type: req_rsp
        end_idx: -1
        act: rsp
        suffix: rsp
        default: ""
      }
      {
        package: tlul_pkg
        struct: tl_h2d
        signame: mio_main_tl_mbx1__sram_req
        width: 1
        type: req_rsp
        end_idx: -1
        act: rsp
        suffix: req
        default: tlul_pkg::TL_H2D_DEFAULT
      }
      {
        package: tlul_pkg
        struct: tl_d2h
        signame: mio_main_tl_mbx1__sram_rsp
        width: 1
        type: req_rsp
        end_idx: -1
        act: rsp
        suffix: rsp
        default: ""
      }
      {
        package: tlul_pkg
        struct: tl_h2d
        signame: mbx2_core_tl_d_req
        width: 1
        type: req_rsp
        end_idx: -1
        act: rsp
        suffix: req
        default: tlul_pkg::TL_H2D_DEFAULT
      }
      {
        package: tlul_pkg
        struct: tl_d2h
        signame: mbx2_core_tl_d_rsp
        width: 1
        type: req_rsp
        end_idx: -1
        act: rsp
        suffix: rsp
        default: ""
      }
      {
        package: tlul_pkg
        struct: tl_h2d
        signame: mio_main_tl_mbx2__sram_req
        width: 1
        type: req_rsp
        end_idx: -1
        act: rsp
        suffix: req
        default: tlul_pkg::TL_H2D_DEFAULT
      }
      {
        package: tlul_pkg
        struct: tl_d2h
        signame: mio_main_tl_mbx2__sram_rsp
        width: 1
        type: req_rsp
        end_idx: -1
        act: rsp
        suffix: rsp
        default: ""
      }
      {
        package: tlul_pkg
        struct: tl_h2d
        signame: mbx3_core_tl_d_req
        width: 1
        type: req_rsp
        end_idx: -1
        act: rsp
        suffix: req
        default: tlul_pkg::TL_H2D_DEFAULT
      }
      {
        package: tlul_pkg
        struct: tl_d2h
        signame: mbx3_core_tl_d_rsp
        width: 1
        type: req_rsp
        end_idx: -1
        act: rsp
        suffix: rsp
        default: ""
      }
      {
        package: tlul_pkg
        struct: tl_h2d
        signame: mio_main_tl_mbx3__sram_req
        width: 1
        type: req_rsp
        end_idx: -1
        act: rsp
        suffix: req
        default: tlul_pkg::TL_H2D_DEFAULT
      }
      {
        package: tlul_pkg
        struct: tl_d2h
        signame: mio_main_tl_mbx3__sram_rsp
        width: 1
        type: req_rsp
        end_idx: -1
        act: rsp
        suffix: rsp
        default: ""
      }
      {
        package: tlul_pkg
        struct: tl_h2d
        signame: mbx4_core_tl_d_req
        width: 1
        type: req_rsp
        end_idx: -1
        act: rsp
        suffix: req
        default: tlul_pkg::TL_H2D_DEFAULT
      }
      {
        package: tlul_pkg
        struct: tl_d2h
        signame: mbx4_core_tl_d_rsp
        width: 1
        type: req_rsp
        end_idx: -1
        act: rsp
        suffix: rsp
        default: ""
      }
      {
        package: tlul_pkg
        struct: tl_h2d
        signame: mio_main_tl_mbx4__sram_req
        width: 1
        type: req_rsp
        end_idx: -1
        act: rsp
        suffix: req
        default: tlul_pkg::TL_H2D_DEFAULT
      }
      {
        package: tlul_pkg
        struct: tl_d2h
        signame: mio_main_tl_mbx4__sram_rsp
        width: 1
        type: req_rsp
        end_idx: -1
        act: rsp
        suffix: rsp
        default: ""
      }
      {
        package: tlul_pkg
        struct: tl_h2d
        signame: mbx5_core_tl_d_req
        width: 1
        type: req_rsp
        end_idx: -1
        act: rsp
        suffix: req
        default: tlul_pkg::TL_H2D_DEFAULT
      }
      {
        package: tlul_pkg
        struct: tl_d2h
        signame: mbx5_core_tl_d_rsp
        width: 1
        type: req_rsp
        end_idx: -1
        act: rsp
        suffix: rsp
        default: ""
      }
      {
        package: tlul_pkg
        struct: tl_h2d
        signame: mio_main_tl_mbx5__sram_req
        width: 1
        type: req_rsp
        end_idx: -1
        act: rsp
        suffix: req
        default: tlul_pkg::TL_H2D_DEFAULT
      }
      {
        package: tlul_pkg
        struct: tl_d2h
        signame: mio_main_tl_mbx5__sram_rsp
        width: 1
        type: req_rsp
        end_idx: -1
        act: rsp
        suffix: rsp
        default: ""
      }
      {
        package: tlul_pkg
        struct: tl_h2d
        signame: mbx_pcie0_core_tl_d_req
        width: 1
        type: req_rsp
        end_idx: -1
        act: rsp
        suffix: req
        default: tlul_pkg::TL_H2D_DEFAULT
      }
      {
        package: tlul_pkg
        struct: tl_d2h
        signame: mbx_pcie0_core_tl_d_rsp
        width: 1
        type: req_rsp
        end_idx: -1
        act: rsp
        suffix: rsp
        default: ""
      }
      {
        package: tlul_pkg
        struct: tl_h2d
        signame: mio_main_tl_mbx_pcie0__sram_req
        width: 1
        type: req_rsp
        end_idx: -1
        act: rsp
        suffix: req
        default: tlul_pkg::TL_H2D_DEFAULT
      }
      {
        package: tlul_pkg
        struct: tl_d2h
        signame: mio_main_tl_mbx_pcie0__sram_rsp
        width: 1
        type: req_rsp
        end_idx: -1
        act: rsp
        suffix: rsp
        default: ""
      }
      {
        package: tlul_pkg
        struct: tl_h2d
        signame: rv_timer_tl_req
        width: 1
        type: req_rsp
        end_idx: -1
        act: rsp
        suffix: req
        default: tlul_pkg::TL_H2D_DEFAULT
      }
      {
        package: tlul_pkg
        struct: tl_d2h
        signame: rv_timer_tl_rsp
        width: 1
        type: req_rsp
        end_idx: -1
        act: rsp
        suffix: rsp
        default: ""
      }
      {
        package: tlul_pkg
        struct: tl_h2d
        signame: sram_ctrl_ret_aon_regs_tl_req
        width: 1
        type: req_rsp
        end_idx: -1
        act: rsp
        suffix: req
        default: tlul_pkg::TL_H2D_DEFAULT
      }
      {
        package: tlul_pkg
        struct: tl_d2h
        signame: sram_ctrl_ret_aon_regs_tl_rsp
        width: 1
        type: req_rsp
        end_idx: -1
        act: rsp
        suffix: rsp
        default: ""
      }
      {
        package: tlul_pkg
        struct: tl_h2d
        signame: sram_ctrl_ret_aon_ram_tl_req
        width: 1
        type: req_rsp
        end_idx: -1
        act: rsp
        suffix: req
        default: tlul_pkg::TL_H2D_DEFAULT
      }
      {
        package: tlul_pkg
        struct: tl_d2h
        signame: sram_ctrl_ret_aon_ram_tl_rsp
        width: 1
        type: req_rsp
        end_idx: -1
        act: rsp
        suffix: rsp
        default: ""
      }
      {
        package: tlul_pkg
        struct: tl_h2d
        signame: aon_timer_aon_tl_req
        width: 1
        type: req_rsp
        end_idx: -1
        act: rsp
        suffix: req
        default: tlul_pkg::TL_H2D_DEFAULT
      }
      {
        package: tlul_pkg
        struct: tl_d2h
        signame: aon_timer_aon_tl_rsp
        width: 1
        type: req_rsp
        end_idx: -1
        act: rsp
        suffix: rsp
        default: ""
      }
      {
        package: tlul_pkg
        struct: tl_h2d
        signame: mbx0_soc_tl_d_req
        width: 1
        type: req_rsp
        end_idx: -1
        act: rsp
        suffix: req
        default: tlul_pkg::TL_H2D_DEFAULT
      }
      {
        package: tlul_pkg
        struct: tl_d2h
        signame: mbx0_soc_tl_d_rsp
        width: 1
        type: req_rsp
        end_idx: -1
        act: rsp
        suffix: rsp
        default: ""
      }
      {
        package: tlul_pkg
        struct: tl_h2d
        signame: mbx1_soc_tl_d_req
        width: 1
        type: req_rsp
        end_idx: -1
        act: rsp
        suffix: req
        default: tlul_pkg::TL_H2D_DEFAULT
      }
      {
        package: tlul_pkg
        struct: tl_d2h
        signame: mbx1_soc_tl_d_rsp
        width: 1
        type: req_rsp
        end_idx: -1
        act: rsp
        suffix: rsp
        default: ""
      }
      {
        package: tlul_pkg
        struct: tl_h2d
        signame: mbx2_soc_tl_d_req
        width: 1
        type: req_rsp
        end_idx: -1
        act: rsp
        suffix: req
        default: tlul_pkg::TL_H2D_DEFAULT
      }
      {
        package: tlul_pkg
        struct: tl_d2h
        signame: mbx2_soc_tl_d_rsp
        width: 1
        type: req_rsp
        end_idx: -1
        act: rsp
        suffix: rsp
        default: ""
      }
      {
        package: tlul_pkg
        struct: tl_h2d
        signame: mbx3_soc_tl_d_req
        width: 1
        type: req_rsp
        end_idx: -1
        act: rsp
        suffix: req
        default: tlul_pkg::TL_H2D_DEFAULT
      }
      {
        package: tlul_pkg
        struct: tl_d2h
        signame: mbx3_soc_tl_d_rsp
        width: 1
        type: req_rsp
        end_idx: -1
        act: rsp
        suffix: rsp
        default: ""
      }
      {
        package: tlul_pkg
        struct: tl_h2d
        signame: mbx4_soc_tl_d_req
        width: 1
        type: req_rsp
        end_idx: -1
        act: rsp
        suffix: req
        default: tlul_pkg::TL_H2D_DEFAULT
      }
      {
        package: tlul_pkg
        struct: tl_d2h
        signame: mbx4_soc_tl_d_rsp
        width: 1
        type: req_rsp
        end_idx: -1
        act: rsp
        suffix: rsp
        default: ""
      }
      {
        package: tlul_pkg
        struct: tl_h2d
        signame: mbx5_soc_tl_d_req
        width: 1
        type: req_rsp
        end_idx: -1
        act: rsp
        suffix: req
        default: tlul_pkg::TL_H2D_DEFAULT
      }
      {
        package: tlul_pkg
        struct: tl_d2h
        signame: mbx5_soc_tl_d_rsp
        width: 1
        type: req_rsp
        end_idx: -1
        act: rsp
        suffix: rsp
        default: ""
      }
      {
        package: tlul_pkg
        struct: tl_h2d
        signame: mbx_pcie0_soc_tl_d_req
        width: 1
        type: req_rsp
        end_idx: -1
        act: rsp
        suffix: req
        default: tlul_pkg::TL_H2D_DEFAULT
      }
      {
        package: tlul_pkg
        struct: tl_d2h
        signame: mbx_pcie0_soc_tl_d_rsp
        width: 1
        type: req_rsp
        end_idx: -1
        act: rsp
        suffix: rsp
        default: ""
      }
      {
        package: tlul_pkg
        struct: tl_h2d
        signame: racl_ctrl_mio_tl_req
        width: 1
        type: req_rsp
        end_idx: -1
        act: rsp
        suffix: req
        default: tlul_pkg::TL_H2D_DEFAULT
      }
      {
        package: tlul_pkg
        struct: tl_d2h
        signame: racl_ctrl_mio_tl_rsp
        width: 1
        type: req_rsp
        end_idx: -1
        act: rsp
        suffix: rsp
        default: ""
      }
      {
        package: tlul_pkg
        struct: tl_h2d
        signame: ac_range_check_mio_tl_req
        width: 1
        type: req_rsp
        end_idx: -1
        act: rsp
        suffix: req
        default: tlul_pkg::TL_H2D_DEFAULT
      }
      {
        package: tlul_pkg
        struct: tl_d2h
        signame: ac_range_check_mio_tl_rsp
        width: 1
        type: req_rsp
        end_idx: -1
        act: rsp
        suffix: rsp
        default: ""
      }
      {
        package: top_racl_pkg
        struct: racl_policy_vec
        signame: racl_ctrl_mio_racl_policies
        width: 1
        type: uni
        end_idx: -1
        act: req
        suffix: ""
        default: top_racl_pkg::RACL_POLICY_VEC_DEFAULT
      }
      {
        package: top_racl_pkg
        struct: racl_error_log
        signame: racl_ctrl_mio_racl_error
        width:
        {
          name: NumSubscribingIps
          desc: Number of subscribing RACL IPs
          param_type: int
          unpacked_dimensions: null
          default: 17
          local: true
          expose: true
          name_top: RaclCtrlMioNumSubscribingIps
        }
        type: uni
        end_idx: -1
        act: rcv
        suffix: ""
        default: top_racl_pkg::RACL_ERROR_LOG_DEFAULT
      }
      {
        package: ""
        struct: logic
        signame: rv_core_ibex_mio_irq_timer
        width: 1
        type: uni
        end_idx: -1
        default: ""
      }
      {
        package: ""
        struct: logic
        signame: rv_core_ibex_mio_hart_id
        width: 32
        type: uni
        end_idx: -1
        default: ""
      }
      {
        package: prim_mubi_pkg
        struct: mubi8
        signame: rv_dm_otp_dis_rv_dm_late_debug
        width: 1
        type: uni
        end_idx: -1
        default: prim_mubi_pkg::MuBi8False
      }
    ]
  }
}
