// Copyright lowRISC contributors (OpenTitan project).
// Licensed under the Apache License, Version 2.0, see LICENSE for details.
// SPDX-License-Identifier: Apache-2.0
//
// ------------------- W A R N I N G: A U T O - G E N E R A T E D   C O D E !! -------------------//
// PLEASE DO NOT HAND-EDIT THIS FILE. IT HAS BEEN AUTO-GENERATED WITH THE FOLLOWING COMMAND:
//
// util/topgen.py -t hw/top_pwc/data/top_pwc.hjson \
//                -o hw/top_pwc/ \
//                --rnd_cnst_seed 1017106219537032642877583828875051302543807092889754935647094601236425074047
{
  name: pwc
  type: top
  rnd_cnst_seed: 1017106219537032642877583828875051302543807092889754935647094601236425074047
  datawidth: "32"
  power:
  {
    domains:
    [
      "0"
    ]
    default: "0"
    wait_for_external_reset: true
  }
  unmanaged_clocks:
  {
    ext_io_div4:
    {
      name: ext_io_div4
      signal_name: clk_ext_io_div4_i
      cg_en_signal: cg_en_ext_io_div4_i
    }
    ext_main:
    {
      name: ext_main
      signal_name: clk_ext_main_i
      cg_en_signal: cg_en_ext_main_i
    }
    ext_aon:
    {
      name: ext_aon
      signal_name: clk_ext_aon_i
      cg_en_signal: cg_en_ext_aon_i
    }
  }
  unmanaged_resets:
  {
    ext_rst_io_div4:
    {
      name: ext_rst_io_div4
      signal_name: rst_ext_rst_io_div4_i
      rst_en_signal_name: rst_en_ext_rst_io_div4_i
    }
    ext_rst_main:
    {
      name: ext_rst_main
      signal_name: rst_ext_rst_main_i
      rst_en_signal_name: rst_en_ext_rst_main_i
    }
    ext_rst_aon:
    {
      name: ext_rst_aon
      signal_name: rst_ext_rst_aon_i
      rst_en_signal_name: rst_en_ext_rst_aon_i
    }
  }
  clocks:
  {
    hier_paths:
    {
      top: clkmgr_aon_clocks.
      ext: ""
      lpg: clkmgr_aon_cg_en.
    }
    srcs:
    [
      {
        name: main
        aon: no
        freq: "100000000"
        ref: false
      }
      {
        name: io
        aon: no
        freq: "96000000"
        ref: false
      }
      {
        name: usb
        aon: no
        freq: "48000000"
        ref: false
      }
      {
        name: aon
        aon: yes
        freq: "200000"
        ref: true
      }
    ]
    derived_srcs:
    [
      {
        name: io_div2
        aon: no
        freq: "48000000"
        ref: false
        div: "2"
        src: io
      }
      {
        name: io_div4
        aon: no
        freq: "24000000"
        ref: false
        div: "4"
        src: io
      }
    ]
    groups:
    [
      {
        name: ast
        src: ext
        sw_cg: no
        unique: no
        clocks: {}
      }
      {
        name: powerup
        src: top
        sw_cg: no
        unique: no
        clocks: {}
      }
      {
        name: trans
        src: top
        sw_cg: hint
        unique: yes
        clocks: {}
      }
      {
        name: infra
        src: top
        sw_cg: no
        unique: no
        clocks: {}
      }
      {
        name: secure
        src: top
        sw_cg: yes
        unique: no
        clocks: {}
      }
      {
        name: peri
        src: top
        sw_cg: yes
        unique: no
        clocks: {}
      }
    ]
  }
  resets:
  {
    hier_paths:
    {
      top: rstmgr_aon_resets.
      ext: ""
      lpg: rstmgr_aon_rst_en.
    }
    nodes:
    [
      {
        name: por_aon
        gen: false
        type: top
        domains: []
        shadowed: false
        sw: false
        path: rstmgr_aon_resets.rst_por_aon_n
        clock: aon
      }
      {
        name: lc_src
        gen: false
        type: int
        domains: []
        shadowed: false
        sw: false
        path: ""
        clock: io_div4
      }
      {
        name: sys_src
        gen: false
        type: int
        domains: []
        shadowed: false
        sw: false
        path: ""
        clock: io_div4
      }
      {
        name: por
        gen: true
        type: top
        domains: []
        shadowed: false
        sw: false
        path: rstmgr_aon_resets.rst_por_n
        parent: por_aon
        clock: main
      }
      {
        name: por_io
        gen: true
        type: top
        domains: []
        shadowed: false
        sw: false
        path: rstmgr_aon_resets.rst_por_io_n
        parent: por_aon
        clock: io
      }
      {
        name: por_io_div2
        gen: true
        type: top
        domains: []
        shadowed: false
        sw: false
        path: rstmgr_aon_resets.rst_por_io_div2_n
        parent: por_aon
        clock: io_div2
      }
      {
        name: por_io_div4
        gen: true
        type: top
        domains: []
        shadowed: false
        sw: false
        path: rstmgr_aon_resets.rst_por_io_div4_n
        parent: por_aon
        clock: io_div4
      }
      {
        name: por_usb
        gen: true
        type: top
        domains: []
        shadowed: false
        sw: false
        path: rstmgr_aon_resets.rst_por_usb_n
        parent: por_aon
        clock: usb
      }
      {
        name: lc
        gen: true
        type: top
        domains: []
        shadowed: false
        sw: false
        path: rstmgr_aon_resets.rst_lc_n
        parent: lc_src
        clock: main
      }
      {
        name: lc_aon
        gen: true
        type: top
        domains: []
        shadowed: false
        sw: false
        path: rstmgr_aon_resets.rst_lc_aon_n
        parent: lc_src
        clock: aon
      }
      {
        name: lc_io
        gen: true
        type: top
        domains: []
        shadowed: false
        sw: false
        path: rstmgr_aon_resets.rst_lc_io_n
        parent: lc_src
        clock: io
      }
      {
        name: lc_io_div2
        gen: true
        type: top
        domains: []
        shadowed: false
        sw: false
        path: rstmgr_aon_resets.rst_lc_io_div2_n
        parent: lc_src
        clock: io_div2
      }
      {
        name: lc_io_div4
        gen: true
        type: top
        domains: []
        shadowed: false
        sw: false
        path: rstmgr_aon_resets.rst_lc_io_div4_n
        parent: lc_src
        clock: io_div4
      }
      {
        name: lc_usb
        gen: true
        type: top
        domains: []
        shadowed: false
        sw: false
        path: rstmgr_aon_resets.rst_lc_usb_n
        parent: lc_src
        clock: usb
      }
      {
        name: sys
        gen: true
        type: top
        domains: []
        shadowed: false
        sw: true
        path: rstmgr_aon_resets.rst_sys_n
        parent: sys_src
        clock: main
      }
    ]
  }
  num_cores: "1"
  addr_spaces:
  [
    {
      name: hart
      desc: The main address space, shared between the CPU and DM
      subspaces:
      [
        {
          name: mpwc
          desc:
            '''
            MMIO region excludes any memory that is separate from the module configuration
            space, i.e. ROM, main SRAM, and mbx SRAM are excluded but retention SRAM or
            spi_device are included.
            '''
          nodes:
          [
            gpio
            rv_timer
            rstmgr_aon
            aon_timer_aon
            soc_proxy.core
            sram_ctrl_ret_aon
            rv_plic
            sram_ctrl_main.regs
            sram_ctrl_mbox.regs
            dma
            mbx0.core
            mbx1.core
            mbx2.core
            mbx3.core
            mbx4.core
            mbx5.core
            rv_core_ibex
          ]
        }
      ]
    }
    {
      name: soc_mbx
      desc: SoC address space for mailbox access
    }
    {
      name: soc_dbg
      desc: SoC address space for debug module interfaces
    }
  ]
  module:
  [
    {
      name: gpio
      type: gpio
      clock_srcs:
      {
        clk_i: ext_io_div4
      }
      clock_group: peri
      reset_connections:
      {
        rst_ni:
        {
          name: ext_rst_io_div4
          domain: "0"
        }
      }
      param_decl:
      {
        GpioAsHwStrapsEn: "0"
        GpioAsyncOn: "1"
      }
      outgoing_alert: pwc
      clock_connections:
      {
        clk_i: clk_ext_io_div4_i
      }
      domain:
      [
        "0"
      ]
      memory: {}
      param_list:
      [
        {
          name: GpioAsyncOn
          desc: Instantiates 2-flop synchronizers on all GPIO inputs if set to 1.
          type: bit
          default: "1"
          local: "false"
          expose: "true"
          name_top: GpioGpioAsyncOn
        }
        {
          name: GpioAsHwStrapsEn
          desc: Enable HW straps sampling logic for GPIO inputs at initial cold boot
          type: bit
          default: "0"
          local: "false"
          expose: "true"
          name_top: GpioGpioAsHwStrapsEn
        }
      ]
      inter_signal_list:
      [
        {
          name: strap_en
          desc: This signal is pulsed high by the power manager after reset in order to sample the HW straps.
          struct: logic
          type: uni
          act: rcv
          width: 1
          default: 1'b0
          inst_name: gpio
          index: -1
        }
        {
          name: sampled_straps
          desc: This vector contains the sampled strap values.
          struct: gpio_straps
          package: gpio_pkg
          type: uni
          act: req
          width: 1
          default: "'0"
          inst_name: gpio
          index: -1
        }
        {
          name: tl
          struct: tl
          package: tlul_pkg
          type: req_rsp
          act: rsp
          width: 1
          inst_name: gpio
          default: ""
          end_idx: -1
          top_signame: gpio_tl
          index: -1
        }
      ]
      base_addrs:
      {
        null:
        {
          hart: 0x30000000
        }
      }
      generate_dif: true
    }
    {
      name: rv_timer
      type: rv_timer
      clock_srcs:
      {
        clk_i: ext_io_div4
      }
      reset_connections:
      {
        rst_ni:
        {
          name: ext_rst_io_div4
          domain: "0"
        }
      }
      outgoing_alert: pwc
      clock_group: secure
      clock_connections:
      {
        clk_i: clk_ext_io_div4_i
      }
      domain:
      [
        "0"
      ]
      param_decl: {}
      param_list: []
      inter_signal_list:
      [
        {
          name: tl
          struct: tl
          package: tlul_pkg
          type: req_rsp
          act: rsp
          width: 1
          inst_name: rv_timer
          default: ""
          end_idx: -1
          top_signame: rv_timer_tl
          index: -1
        }
      ]
      base_addrs:
      {
        null:
        {
          hart: 0x30100000
        }
      }
      generate_dif: true
    }
    {
      name: aon_timer_aon
      type: aon_timer
      clock_srcs:
      {
        clk_i: ext_io_div4
        clk_aon_i: ext_aon
      }
      reset_connections:
      {
        rst_ni:
        {
          name: ext_rst_io_div4
          domain: "0"
        }
        rst_aon_ni:
        {
          name: ext_rst_aon
          domain: "0"
        }
      }
      domain:
      [
        "0"
      ]
      outgoing_alert: pwc
      clock_group: secure
      clock_connections:
      {
        clk_i: clk_ext_io_div4_i
        clk_aon_i: clk_ext_aon_i
      }
      param_decl: {}
      param_list: []
      inter_signal_list:
      [
        {
          name: nmi_wdog_timer_bark
          struct: logic
          type: uni
          act: req
          width: 1
          default: 1'b0
          inst_name: aon_timer_aon
          package: ""
          end_idx: -1
          top_type: broadcast
          top_signame: aon_timer_aon_nmi_wdog_timer_bark
          index: -1
        }
        {
          name: wkup_req
          struct: logic
          type: uni
          act: req
          width: 1
          default: 1'b0
          inst_name: aon_timer_aon
          index: -1
        }
        {
          name: aon_timer_rst_req
          struct: logic
          type: uni
          act: req
          width: 1
          default: 1'b0
          inst_name: aon_timer_aon
          index: -1
        }
        {
          name: lc_escalate_en
          struct: lc_tx
          package: lc_ctrl_pkg
          type: uni
          act: rcv
          width: 1
          default: lc_ctrl_pkg::Off
          inst_name: aon_timer_aon
          top_signame: soc_proxy_lc_escalate_en
          index: -1
        }
        {
          name: sleep_mode
          struct: logic
          type: uni
          act: rcv
          width: 1
          inst_name: aon_timer_aon
          index: -1
        }
        {
          name: tl
          struct: tl
          package: tlul_pkg
          type: req_rsp
          act: rsp
          width: 1
          inst_name: aon_timer_aon
          default: ""
          end_idx: -1
          top_signame: aon_timer_aon_tl
          index: -1
        }
      ]
      base_addrs:
      {
        null:
        {
          hart: 0x30470000
        }
      }
      generate_dif: true
    }
    {
      name: soc_proxy
      type: soc_proxy
      clock_srcs:
      {
        clk_i: ext_main
      }
      reset_connections:
      {
        rst_ni:
        {
          name: ext_rst_main
          domain: "0"
        }
      }
      domain:
      [
        "0"
      ]
      base_addrs:
      {
        core:
        {
          hart: 0x22030000
        }
        ctn:
        {
          hart: 0x40000000
        }
      }
      attr: reggen_top
      memory:
      {
        ctn:
        {
          label: ctn
          swaccess: rw
          data_intg_passthru: "true"
          exec: True
          byte_write: True
          size: 0x40000000
        }
      }
      outgoing_alert: pwc
      clock_group: secure
      clock_connections:
      {
        clk_i: clk_ext_main_i
      }
      param_decl: {}
      param_list: []
      inter_signal_list:
      [
        {
          name: lc_escalate_en
          desc:
            '''
            Escalation enable signal coming from life cycle controller, used for invalidating
            the latched lc_hw_debug_en state inside the strap sampling logic.
            '''
          struct: lc_tx
          package: lc_ctrl_pkg
          type: uni
          act: req
          width: 1
          default: lc_ctrl_pkg::Off
          inst_name: soc_proxy
          end_idx: -1
          top_type: broadcast
          top_signame: soc_proxy_lc_escalate_en
          index: -1
        }
        {
          name: lc_escalate_en_ext
          desc:
            '''
            Escalation enable signal coming from life cycle controller, used for invalidating
            the latched lc_hw_debug_en state inside the strap sampling logic.
            '''
          struct: lc_tx
          package: lc_ctrl_pkg
          type: uni
          act: rcv
          width: 1
          default: lc_ctrl_pkg::Off
          inst_name: soc_proxy
          external: true
          top_signame: lc_escalate_en_ext
          conn_type: false
          index: -1
        }
        {
          name: lc_hw_debug_en
          desc:
            '''
            Multibit life cycle hardware debug enable signal coming from life cycle controller,
            asserted when the hardware debug mechanisms are enabled in the system.
            '''
          struct: lc_tx
          package: lc_ctrl_pkg
          type: uni
          act: req
          width: 1
          default: lc_ctrl_pkg::Off
          inst_name: soc_proxy
          end_idx: -1
          top_type: broadcast
          top_signame: soc_proxy_lc_hw_debug_en
          index: -1
        }
        {
          name: lc_hw_debug_en_ext
          desc:
            '''
            Multibit life cycle hardware debug enable signal coming from life cycle controller,
            asserted when the hardware debug mechanisms are enabled in the system.
            '''
          struct: lc_tx
          package: lc_ctrl_pkg
          type: uni
          act: rcv
          width: 1
          default: lc_ctrl_pkg::Off
          inst_name: soc_proxy
          external: true
          top_signame: lc_hw_debug_en_ext
          conn_type: false
          index: -1
        }
        {
          name: ctn_tl_h2d
          desc: TL-UL host port for egress into CTN (request part), synchronous
          struct: tl_h2d
          package: tlul_pkg
          type: uni
          act: req
          width: 1
          inst_name: soc_proxy
          default: ""
          external: true
          top_signame: ctn_tl_h2d
          conn_type: false
          index: -1
        }
        {
          name: ctn_tl_d2h
          desc: TL-UL host port for egress into CTN (response part), synchronous
          struct: tl_d2h
          package: tlul_pkg
          type: uni
          act: rcv
          width: 1
          inst_name: soc_proxy
          default: ""
          external: true
          top_signame: ctn_tl_d2h
          conn_type: false
          index: -1
        }
        {
          name: soc_lsio_trigger
          desc: LSIO trigger signal from SoC, synchronous
          struct: logic
          type: uni
          act: rcv
          width: 8
          inst_name: soc_proxy
          default: ""
          package: ""
          external: true
          top_signame: soc_lsio_trigger
          conn_type: false
          index: -1
        }
        {
          name: dma_lsio_trigger
          desc: Collated synchronous LSIO trigger signals for DMA
          struct: lsio_trigger
          package: dma_pkg
          type: uni
          act: req
          width: 1
          inst_name: soc_proxy
          default: ""
          top_signame: dma_lsio_trigger
          index: -1
        }
        {
          name: soc_intr_async
          desc: Interrupt request from SoC, asynchronous, level-encoded
          struct: logic
          type: uni
          act: rcv
          width: 32
          inst_name: soc_proxy
          index: -1
        }
        {
          name: mubi8_true
          struct: mubi8
          package: prim_mubi_pkg
          type: uni
          act: req
          width: 1
          default: prim_mubi_pkg::MuBi8False
          inst_name: soc_proxy
          top_signame: sram_ctrl_main_otp_en_sram_ifetch
          index: -1
        }
        {
          name: core_tl
          struct: tl
          package: tlul_pkg
          type: req_rsp
          act: rsp
          width: 1
          inst_name: soc_proxy
          default: ""
          end_idx: -1
          top_signame: soc_proxy_core_tl
          index: -1
        }
        {
          name: ctn_tl
          struct: tl
          package: tlul_pkg
          type: req_rsp
          act: rsp
          width: 1
          inst_name: soc_proxy
          default: ""
          end_idx: -1
          top_signame: soc_proxy_ctn_tl
          index: -1
        }
      ]
      generate_dif: true
    }
    {
      name: sram_ctrl_ret_aon
      type: sram_ctrl
      clock_srcs:
      {
        clk_i: ext_io_div4
        clk_otp_i: ext_io_div4
      }
      clock_group: infra
      reset_connections:
      {
        rst_ni:
        {
          name: ext_rst_io_div4
          domain: "0"
        }
        rst_otp_ni:
        {
          name: ext_rst_io_div4
          domain: "0"
        }
      }
      domain:
      [
        "0"
      ]
      param_decl:
      {
        InstrExec: "0"
        InstSize: 4096
      }
      base_addrs:
      {
        regs:
        {
          hart: 0x30500000
        }
        ram:
        {
          hart: 0x30600000
        }
      }
      memory:
      {
        ram:
        {
          label: ram_ret_aon
          swaccess: rw
          data_intg_passthru: "true"
          exec: True
          byte_write: True
          size: 0x1000
        }
      }
      outgoing_alert: pwc
      clock_connections:
      {
        clk_i: clk_ext_io_div4_i
        clk_otp_i: clk_ext_io_div4_i
      }
      param_list:
      [
        {
          name: RndCnstSramKey
          desc: Compile-time random reset value for SRAM scrambling key.
          type: otp_ctrl_pkg::sram_key_t
          randcount: 128
          randtype: data
          name_top: RndCnstSramCtrlRetAonSramKey
          default: 0x9d66316fa6c7a2cfe54b57b94ccdb5b7
          randwidth: 128
        }
        {
          name: RndCnstSramNonce
          desc: Compile-time random reset value for SRAM scrambling nonce.
          type: otp_ctrl_pkg::sram_nonce_t
          randcount: 128
          randtype: data
          name_top: RndCnstSramCtrlRetAonSramNonce
          default: 0x1fbc75fa47fd1ee356b0ee77c01530c
          randwidth: 128
        }
        {
          name: RndCnstLfsrSeed
          desc: Compile-time random bits for initial LFSR seed
          type: sram_ctrl_pkg::lfsr_seed_t
          randcount: 32
          randtype: data
          name_top: RndCnstSramCtrlRetAonLfsrSeed
          default: 0xb2628838
          randwidth: 32
        }
        {
          name: RndCnstLfsrPerm
          desc: Compile-time random permutation for LFSR output
          type: sram_ctrl_pkg::lfsr_perm_t
          randcount: 32
          randtype: perm
          name_top: RndCnstSramCtrlRetAonLfsrPerm
          default: 0x4c844a073f640cdc1f6e03d732a395bea23ed95e
          randwidth: 160
        }
        {
          name: MemSizeRam
          desc: Memory size of the RAM (in bytes).
          type: int
          name_top: MemSizeSramCtrlRetAonRam
          default: 4096
        }
        {
          name: InstSize
          desc: Memory size of a single RAM tile (in bytes).
          type: int
          default: 4096
          local: "false"
          expose: "true"
          name_top: SramCtrlRetAonInstSize
        }
        {
          name: NumRamInst
          desc: Number of internal RAM instances. Must be the same as ceil(MemSizeRam / InstSize) .
          type: int
          default: 1
          local: "false"
          expose: "true"
          name_top: SramCtrlRetAonNumRamInst
        }
        {
          name: InstrExec
          desc: Support execution from SRAM
          type: bit
          default: "0"
          local: "false"
          expose: "true"
          name_top: SramCtrlRetAonInstrExec
        }
        {
          name: NumPrinceRoundsHalf
          desc: Number of PRINCE half rounds for the SRAM scrambling feature
          type: int
          default: "3"
          local: "false"
          expose: "true"
          name_top: SramCtrlRetAonNumPrinceRoundsHalf
        }
        {
          name: UseOTIntegErr
          desc: When set to 0, use Rivos error logging
          type: bit
          default: "1"
          local: "false"
          expose: "true"
          name_top: SramCtrlRetAonUseOTIntegErr
        }
        {
          name: UseCompiledRam
          desc: When set to 1, use compiled SRAM macros
          type: bit
          default: "1"
          local: "false"
          expose: "true"
          name_top: SramCtrlRetAonUseCompiledRam
        }
        {
          name: FlopRamOutput
          desc: Flop the output s
          type: bit
          default: "1"
          local: "false"
          expose: "true"
          name_top: SramCtrlRetAonFlopRamOutput
        }
      ]
      inter_signal_list:
      [
        {
          name: sram_otp_key
          struct: sram_otp_key
          package: otp_ctrl_pkg
          type: req_rsp
          act: req
          width: 1
          inst_name: sram_ctrl_ret_aon
          index: -1
        }
        {
          name: cfg
          struct: ram_1p_cfg
          package: prim_ram_1p_pkg
          type: uni
          act: rcv
          width:
          {
            name: NumRamInst
            desc: Number of internal RAM instances. Must be the same as ceil(MemSizeRam / InstSize) .
            param_type: int
            unpacked_dimensions: null
            default: 1
            local: false
            expose: true
            name_top: SramCtrlRetAonNumRamInst
          }
          default: "'0"
          inst_name: sram_ctrl_ret_aon
          external: true
          top_signame: sram_ctrl_ret_aon_ram_1p_cfg
          conn_type: false
          index: -1
        }
        {
          name: cfg_rsp
          struct: ram_1p_cfg_rsp
          package: prim_ram_1p_pkg
          type: uni
          act: req
          width:
          {
            name: NumRamInst
            desc: Number of internal RAM instances. Must be the same as ceil(MemSizeRam / InstSize) .
            param_type: int
            unpacked_dimensions: null
            default: 1
            local: false
            expose: true
            name_top: SramCtrlRetAonNumRamInst
          }
          default: "'0"
          inst_name: sram_ctrl_ret_aon
          external: true
          top_signame: sram_ctrl_ret_aon_ram_1p_cfg_rsp
          conn_type: false
          index: -1
        }
        {
          name: lc_escalate_en
          struct: lc_tx
          package: lc_ctrl_pkg
          type: uni
          act: rcv
          width: 1
          default: lc_ctrl_pkg::Off
          inst_name: sram_ctrl_ret_aon
          top_signame: soc_proxy_lc_escalate_en
          index: -1
        }
        {
          name: lc_hw_debug_en
          struct: lc_tx
          package: lc_ctrl_pkg
          type: uni
          act: rcv
          width: 1
          default: lc_ctrl_pkg::Off
          inst_name: sram_ctrl_ret_aon
          top_signame: soc_proxy_lc_hw_debug_en
          index: -1
        }
        {
          name: otp_en_sram_ifetch
          struct: mubi8
          package: prim_mubi_pkg
          type: uni
          act: rcv
          width: 1
          default: prim_mubi_pkg::MuBi8False
          inst_name: sram_ctrl_ret_aon
          index: -1
        }
        {
          name: sram_error_record_uncor_err
          desc: SRAM Error injection reporting
          struct: logic
          type: uni
          act: req
          width: 1
          inst_name: sram_ctrl_ret_aon
          index: -1
        }
        {
          name: sram_error_record_corr_err
          desc: SRAM Error injection reporting
          struct: logic
          type: uni
          act: req
          width: 1
          inst_name: sram_ctrl_ret_aon
          index: -1
        }
        {
          name: sram_error_record_err_addr
          desc: SRAM Error injection reporting
          struct: logic [top_pkg::TL_AW-1:0]
          type: uni
          act: req
          width: 1
          inst_name: sram_ctrl_ret_aon
          index: -1
        }
        {
          name: regs_tl
          struct: tl
          package: tlul_pkg
          type: req_rsp
          act: rsp
          width: 1
          inst_name: sram_ctrl_ret_aon
          default: ""
          end_idx: -1
          top_signame: sram_ctrl_ret_aon_regs_tl
          index: -1
        }
        {
          name: ram_tl
          struct: tl
          package: tlul_pkg
          type: req_rsp
          act: rsp
          width: 1
          inst_name: sram_ctrl_ret_aon
          default: ""
          end_idx: -1
          top_signame: sram_ctrl_ret_aon_ram_tl
          index: -1
        }
      ]
      generate_dif: true
    }
    {
      name: rv_dm
      type: rv_dm
      clock_srcs:
      {
        clk_i: ext_main
        clk_lc_i: ext_main
      }
      reset_connections:
      {
        rst_ni:
        {
          name: ext_rst_main
          domain: "0"
        }
        rst_lc_ni:
        {
          name: ext_rst_main
          domain: "0"
        }
      }
      base_addrs:
      {
        mem:
        {
          hart: 0x00040000
        }
        regs:
        {
          hart: 0x21200000
        }
        dbg:
        {
          soc_dbg: 0x00000000
        }
      }
      param_decl:
      {
        SecVolatileRawUnlockEn: top_pkg::SecVolatileRawUnlockEn
        UseDmiInterface: "1"
      }
      generate_dif: false
      outgoing_alert: pwc
      clock_group: secure
      clock_connections:
      {
        clk_i: clk_ext_main_i
        clk_lc_i: clk_ext_main_i
      }
      domain:
      [
        "0"
      ]
      memory: {}
      param_list:
      [
        {
          name: IdcodeValue
          desc: RISC-V debug module JTAG ID code.
          type: logic [31:0]
          default: 32'h 0000_0001
          local: "false"
          expose: "true"
          name_top: RvDmIdcodeValue
        }
        {
          name: UseDmiInterface
          desc: When 1, a TLUL-based DMI interface is used. When 0, a JTAG TAP is used.
          type: bit
          default: "1"
          local: "false"
          expose: "true"
          name_top: RvDmUseDmiInterface
        }
        {
          name: SecVolatileRawUnlockEn
          desc:
            '''
            Disable (0) or enable (1) volatile RAW UNLOCK capability.
            If enabled, the strap_en_override_i input can be used to re-sample the straps at runtime.
            IMPORTANT NOTE: This should only be used in test chips. The parameter must be set
            to 0 in production tapeouts since this weakens the security posture of the RAW
            UNLOCK mechanism.
            '''
          type: bit
          default: top_pkg::SecVolatileRawUnlockEn
          local: "false"
          expose: "true"
          name_top: SecRvDmVolatileRawUnlockEn
        }
      ]
      inter_signal_list:
      [
        {
          name: next_dm_addr
          desc:
            '''
            32bit word address of the next debug module.
            Set to 0x0 if this is the last debug module in the chain.
            '''
          struct: next_dm_addr
          package: rv_dm_pkg
          type: uni
          act: rcv
          width: 1
          default: "'0"
          inst_name: rv_dm
          external: true
          top_signame: rv_dm_next_dm_addr
          conn_type: false
          index: -1
        }
        {
          name: jtag
          desc: JTAG signals for the RISC-V TAP.
          struct: jtag
          package: jtag_pkg
          type: req_rsp
          act: rsp
          width: 1
          inst_name: rv_dm
          index: -1
        }
        {
          name: lc_hw_debug_en
          desc:
            '''
            Multibit life cycle hardware debug enable signal coming from life cycle controller,
            asserted when the hardware debug mechanisms are enabled in the system.
            '''
          struct: lc_tx
          package: lc_ctrl_pkg
          type: uni
          act: rcv
          width: 1
          default: lc_ctrl_pkg::Off
          inst_name: rv_dm
          top_signame: soc_proxy_lc_hw_debug_en
          index: -1
        }
        {
          name: lc_dft_en
          desc:
            '''
            Multibit life cycle hardware debug enable signal coming from life cycle controller,
            asserted when the DFT mechanisms are enabled in the system.
            '''
          struct: lc_tx
          package: lc_ctrl_pkg
          type: uni
          act: rcv
          width: 1
          default: lc_ctrl_pkg::Off
          inst_name: rv_dm
          index: -1
        }
        {
          name: pinmux_hw_debug_en
          desc:
            '''
            Multibit life cycle hardware debug enable signal coming from pinmux.
            This is a latched version of the lc_hw_debug_en signal and is only used to
            gate the JTAG / TAP side of the RV_DM. It is used to keep a debug session live
            while the rest of the system undergoes an NDM reset.
            '''
          struct: lc_tx
          package: lc_ctrl_pkg
          type: uni
          act: rcv
          width: 1
          default: lc_ctrl_pkg::Off
          inst_name: rv_dm
          index: -1
        }
        {
          name: otp_dis_rv_dm_late_debug
          struct: mubi8
          package: prim_mubi_pkg
          type: uni
          act: rcv
          width: 1
          default: prim_mubi_pkg::MuBi8False
          inst_name: rv_dm
          index: -1
        }
        {
          name: unavailable
          desc:
            '''
            This signal indicates to the debug module that the main processor is not available
            for debug (e.g. due to a low-power state).
            '''
          struct: logic
          type: uni
          act: rcv
          width: 1
          default: 1'b0
          inst_name: rv_dm
          index: -1
        }
        {
          name: ndmreset_req
          desc: Non-debug module reset request going to the system reset infrastructure.
          struct: logic
          type: uni
          act: req
          width: 1
          inst_name: rv_dm
          index: -1
        }
        {
          name: dmactive
          desc:
            '''
            This signal indicates whether the debug module is active and can be used to prevent
            power down of the core and bus-attached peripherals.
            '''
          struct: logic
          type: uni
          act: req
          width: 1
          inst_name: rv_dm
          index: -1
        }
        {
          name: debug_req
          desc: This is the debug request interrupt going to the main processor.
          struct: logic [rv_dm_reg_pkg::NrHarts-1:0]
          type: uni
          act: req
          width: 1
          inst_name: rv_dm
          default: ""
          package: ""
          end_idx: -1
          top_type: broadcast
          top_signame: rv_dm_debug_req
          index: -1
        }
        {
          name: lc_escalate_en
          desc:
            '''
            Escalation enable signal coming from life cycle controller, used for invalidating
            the latched lc_hw_debug_en state inside the strap sampling logic.
            '''
          struct: lc_tx
          package: lc_ctrl_pkg
          type: uni
          act: rcv
          width: 1
          default: lc_ctrl_pkg::Off
          inst_name: rv_dm
          top_signame: soc_proxy_lc_escalate_en
          index: -1
        }
        {
          name: lc_check_byp_en
          desc:
            '''
            Check bypass enable signal coming from life cycle controller, used for invalidating
            the latched lc_hw_debug_en state inside the strap sampling logic. This signal is asserted
            whenever the life cycle controller performs a life cycle transition. Its main use is
            to skip any background checks inside the life cycle partition of the OTP controller while
            a life cycle transition is in progress.
            '''
          struct: lc_tx
          package: lc_ctrl_pkg
          type: uni
          act: rcv
          width: 1
          default: lc_ctrl_pkg::Off
          inst_name: rv_dm
          external: true
          top_signame: lc_check_byp_en
          conn_type: false
          index: -1
        }
        {
          name: strap_en
          desc: This signal is pulsed high by the power manager after reset in order to sample the HW straps.
          struct: logic
          type: uni
          act: rcv
          width: 1
          default: 1'b0
          inst_name: rv_dm
          index: -1
        }
        {
          name: strap_en_override
          desc:
            '''
            This signal transitions from 0 -> 1 by the lc_ctrl manager after volatile RAW_UNLOCK in order to re-sample the HW straps.
            The signal must stay at 1 until reset.
            Note that this is only used in test chips when SecVolatileRawUnlockEn = 1.
            Otherwise this signal is unused.
            '''
          struct: logic
          type: uni
          act: rcv
          width: 1
          default: 1'b0
          inst_name: rv_dm
          index: -1
        }
        {
          name: sba_tl_h
          struct: tl
          package: tlul_pkg
          type: req_rsp
          act: req
          width: 1
          inst_name: rv_dm
          default: ""
          top_signame: pwc_main_tl_rv_dm__sba
          index: -1
        }
        {
          name: regs_tl_d
          struct: tl
          package: tlul_pkg
          type: req_rsp
          act: rsp
          width: 1
          inst_name: rv_dm
          default: ""
          end_idx: -1
          top_signame: rv_dm_regs_tl_d
          index: -1
        }
        {
          name: mem_tl_d
          struct: tl
          package: tlul_pkg
          type: req_rsp
          act: rsp
          width: 1
          inst_name: rv_dm
          default: ""
          end_idx: -1
          top_signame: rv_dm_mem_tl_d
          index: -1
        }
        {
          name: dbg_tl_d
          struct: tl
          package: tlul_pkg
          type: req_rsp
          act: rsp
          width: 1
          inst_name: rv_dm
          default: ""
          external: true
          top_signame: rv_dm_dbg
          conn_type: false
          index: -1
        }
      ]
    }
    {
      name: rv_plic
      type: rv_plic
      clock_srcs:
      {
        clk_i: ext_main
      }
      clock_group: secure
      reset_connections:
      {
        rst_ni:
        {
          name: ext_rst_main
          domain: "0"
        }
      }
      attr: ipgen
      outgoing_alert: pwc
      incoming_interrupt:
      [
        pwc_external_irq_cfg.hjson
      ]
      clock_connections:
      {
        clk_i: clk_ext_main_i
      }
      domain:
      [
        "0"
      ]
      param_decl: {}
      param_list: []
      inter_signal_list:
      [
        {
          name: irq
          struct: logic
          type: uni
          act: req
          width: 1
          inst_name: rv_plic
          default: ""
          package: ""
          end_idx: -1
          top_type: broadcast
          top_signame: rv_plic_irq
          index: -1
        }
        {
          name: irq_id
          struct: logic
          type: uni
          act: req
          width: 1
          inst_name: rv_plic
          index: -1
        }
        {
          name: msip
          struct: logic
          type: uni
          act: req
          width: 1
          inst_name: rv_plic
          default: ""
          package: ""
          end_idx: -1
          top_type: broadcast
          top_signame: rv_plic_msip
          index: -1
        }
        {
          name: tl
          struct: tl
          package: tlul_pkg
          type: req_rsp
          act: rsp
          width: 1
          inst_name: rv_plic
          default: ""
          end_idx: -1
          top_signame: rv_plic_tl
          index: -1
        }
      ]
      base_addrs:
      {
        null:
        {
          hart: 0x28000000
        }
      }
      generate_dif: true
    }
    {
      name: sram_ctrl_main
      type: sram_ctrl
      clock_srcs:
      {
        clk_i: ext_main
        clk_otp_i: ext_io_div4
      }
      clock_group: infra
      reset_connections:
      {
        rst_ni:
        {
          name: ext_rst_main
          domain: "0"
        }
        rst_otp_ni:
        {
          name: ext_rst_io_div4
          domain: "0"
        }
      }
      param_decl:
      {
        InstrExec: "1"
        InstSize: 65536
      }
      base_addrs:
      {
        regs:
        {
          hart: 0x211c0000
        }
        ram:
        {
          hart: 0x10000000
        }
      }
      memory:
      {
        ram:
        {
          label: ram_main
          swaccess: rw
          data_intg_passthru: "true"
          exec: True
          byte_write: True
          size: 0x10000
        }
      }
      outgoing_alert: pwc
      clock_connections:
      {
        clk_i: clk_ext_main_i
        clk_otp_i: clk_ext_io_div4_i
      }
      domain:
      [
        "0"
      ]
      param_list:
      [
        {
          name: RndCnstSramKey
          desc: Compile-time random reset value for SRAM scrambling key.
          type: otp_ctrl_pkg::sram_key_t
          randcount: 128
          randtype: data
          name_top: RndCnstSramCtrlMainSramKey
          default: 0xacf49bfadf4c4cef4a487a070e2d41c2
          randwidth: 128
        }
        {
          name: RndCnstSramNonce
          desc: Compile-time random reset value for SRAM scrambling nonce.
          type: otp_ctrl_pkg::sram_nonce_t
          randcount: 128
          randtype: data
          name_top: RndCnstSramCtrlMainSramNonce
          default: 0x44cb7240cee69df76619e1bba8167005
          randwidth: 128
        }
        {
          name: RndCnstLfsrSeed
          desc: Compile-time random bits for initial LFSR seed
          type: sram_ctrl_pkg::lfsr_seed_t
          randcount: 32
          randtype: data
          name_top: RndCnstSramCtrlMainLfsrSeed
          default: 0xee5b59b1
          randwidth: 32
        }
        {
          name: RndCnstLfsrPerm
          desc: Compile-time random permutation for LFSR output
          type: sram_ctrl_pkg::lfsr_perm_t
          randcount: 32
          randtype: perm
          name_top: RndCnstSramCtrlMainLfsrPerm
          default: 0x454fb4cfe30833dbb8acc40d25722dd52cb113cf
          randwidth: 160
        }
        {
          name: MemSizeRam
          desc: Memory size of the RAM (in bytes).
          type: int
          name_top: MemSizeSramCtrlMainRam
          default: 65536
        }
        {
          name: InstSize
          desc: Memory size of a single RAM tile (in bytes).
          type: int
          default: 65536
          local: "false"
          expose: "true"
          name_top: SramCtrlMainInstSize
        }
        {
          name: NumRamInst
          desc: Number of internal RAM instances. Must be the same as ceil(MemSizeRam / InstSize) .
          type: int
          default: 1
          local: "false"
          expose: "true"
          name_top: SramCtrlMainNumRamInst
        }
        {
          name: InstrExec
          desc: Support execution from SRAM
          type: bit
          default: "1"
          local: "false"
          expose: "true"
          name_top: SramCtrlMainInstrExec
        }
        {
          name: NumPrinceRoundsHalf
          desc: Number of PRINCE half rounds for the SRAM scrambling feature
          type: int
          default: "3"
          local: "false"
          expose: "true"
          name_top: SramCtrlMainNumPrinceRoundsHalf
        }
        {
          name: UseOTIntegErr
          desc: When set to 0, use Rivos error logging
          type: bit
          default: "1"
          local: "false"
          expose: "true"
          name_top: SramCtrlMainUseOTIntegErr
        }
        {
          name: UseCompiledRam
          desc: When set to 1, use compiled SRAM macros
          type: bit
          default: "1"
          local: "false"
          expose: "true"
          name_top: SramCtrlMainUseCompiledRam
        }
        {
          name: FlopRamOutput
          desc: Flop the output s
          type: bit
          default: "1"
          local: "false"
          expose: "true"
          name_top: SramCtrlMainFlopRamOutput
        }
      ]
      inter_signal_list:
      [
        {
          name: sram_otp_key
          struct: sram_otp_key
          package: otp_ctrl_pkg
          type: req_rsp
          act: req
          width: 1
          inst_name: sram_ctrl_main
          index: -1
        }
        {
          name: cfg
          struct: ram_1p_cfg
          package: prim_ram_1p_pkg
          type: uni
          act: rcv
          width:
          {
            name: NumRamInst
            desc: Number of internal RAM instances. Must be the same as ceil(MemSizeRam / InstSize) .
            param_type: int
            unpacked_dimensions: null
            default: 1
            local: false
            expose: true
            name_top: SramCtrlMainNumRamInst
          }
          default: "'0"
          inst_name: sram_ctrl_main
          external: true
          top_signame: sram_ctrl_main_ram_1p_cfg
          conn_type: false
          index: -1
        }
        {
          name: cfg_rsp
          struct: ram_1p_cfg_rsp
          package: prim_ram_1p_pkg
          type: uni
          act: req
          width:
          {
            name: NumRamInst
            desc: Number of internal RAM instances. Must be the same as ceil(MemSizeRam / InstSize) .
            param_type: int
            unpacked_dimensions: null
            default: 1
            local: false
            expose: true
            name_top: SramCtrlMainNumRamInst
          }
          default: "'0"
          inst_name: sram_ctrl_main
          external: true
          top_signame: sram_ctrl_main_ram_1p_cfg_rsp
          conn_type: false
          index: -1
        }
        {
          name: lc_escalate_en
          struct: lc_tx
          package: lc_ctrl_pkg
          type: uni
          act: rcv
          width: 1
          default: lc_ctrl_pkg::Off
          inst_name: sram_ctrl_main
          top_signame: soc_proxy_lc_escalate_en
          index: -1
        }
        {
          name: lc_hw_debug_en
          struct: lc_tx
          package: lc_ctrl_pkg
          type: uni
          act: rcv
          width: 1
          default: lc_ctrl_pkg::Off
          inst_name: sram_ctrl_main
          top_signame: soc_proxy_lc_hw_debug_en
          index: -1
        }
        {
          name: otp_en_sram_ifetch
          struct: mubi8
          package: prim_mubi_pkg
          type: uni
          act: rcv
          width: 1
          default: prim_mubi_pkg::MuBi8False
          inst_name: sram_ctrl_main
          end_idx: -1
          top_type: broadcast
          top_signame: sram_ctrl_main_otp_en_sram_ifetch
          index: -1
        }
        {
          name: sram_error_record_uncor_err
          desc: SRAM Error injection reporting
          struct: logic
          type: uni
          act: req
          width: 1
          inst_name: sram_ctrl_main
          index: -1
        }
        {
          name: sram_error_record_corr_err
          desc: SRAM Error injection reporting
          struct: logic
          type: uni
          act: req
          width: 1
          inst_name: sram_ctrl_main
          index: -1
        }
        {
          name: sram_error_record_err_addr
          desc: SRAM Error injection reporting
          struct: logic [top_pkg::TL_AW-1:0]
          type: uni
          act: req
          width: 1
          inst_name: sram_ctrl_main
          index: -1
        }
        {
          name: regs_tl
          struct: tl
          package: tlul_pkg
          type: req_rsp
          act: rsp
          width: 1
          inst_name: sram_ctrl_main
          default: ""
          end_idx: -1
          top_signame: sram_ctrl_main_regs_tl
          index: -1
        }
        {
          name: ram_tl
          struct: tl
          package: tlul_pkg
          type: req_rsp
          act: rsp
          width: 1
          inst_name: sram_ctrl_main
          default: ""
          end_idx: -1
          top_signame: sram_ctrl_main_ram_tl
          index: -1
        }
      ]
      generate_dif: true
    }
    {
      name: sram_ctrl_mbox
      type: sram_ctrl
      clock_srcs:
      {
        clk_i: ext_main
        clk_otp_i: ext_io_div4
      }
      clock_group: infra
      reset_connections:
      {
        rst_ni:
        {
          name: ext_rst_main
          domain: "0"
        }
        rst_otp_ni:
        {
          name: ext_rst_io_div4
          domain: "0"
        }
      }
      param_decl:
      {
        InstrExec: "0"
        InstSize: 4096
      }
      base_addrs:
      {
        regs:
        {
          hart: 0x211d0000
        }
        ram:
        {
          hart: 0x11000000
        }
      }
      memory:
      {
        ram:
        {
          label: ram_mbox
          swaccess: rw
          data_intg_passthru: "true"
          exec: False
          byte_write: True
          size: 0x1000
        }
      }
      outgoing_alert: pwc
      clock_connections:
      {
        clk_i: clk_ext_main_i
        clk_otp_i: clk_ext_io_div4_i
      }
      domain:
      [
        "0"
      ]
      param_list:
      [
        {
          name: RndCnstSramKey
          desc: Compile-time random reset value for SRAM scrambling key.
          type: otp_ctrl_pkg::sram_key_t
          randcount: 128
          randtype: data
          name_top: RndCnstSramCtrlMboxSramKey
          default: 0x7fc9bd14102dc30c29978a4c70c8da26
          randwidth: 128
        }
        {
          name: RndCnstSramNonce
          desc: Compile-time random reset value for SRAM scrambling nonce.
          type: otp_ctrl_pkg::sram_nonce_t
          randcount: 128
          randtype: data
          name_top: RndCnstSramCtrlMboxSramNonce
          default: 0xcb202f5f59a412a3392b9403c190120b
          randwidth: 128
        }
        {
          name: RndCnstLfsrSeed
          desc: Compile-time random bits for initial LFSR seed
          type: sram_ctrl_pkg::lfsr_seed_t
          randcount: 32
          randtype: data
          name_top: RndCnstSramCtrlMboxLfsrSeed
          default: 0xb318a937
          randwidth: 32
        }
        {
          name: RndCnstLfsrPerm
          desc: Compile-time random permutation for LFSR output
          type: sram_ctrl_pkg::lfsr_perm_t
          randcount: 32
          randtype: perm
          name_top: RndCnstSramCtrlMboxLfsrPerm
          default: 0xb0f0e3bd20adc9d9aff2889192c3413329b579bc
          randwidth: 160
        }
        {
          name: MemSizeRam
          desc: Memory size of the RAM (in bytes).
          type: int
          name_top: MemSizeSramCtrlMboxRam
          default: 4096
        }
        {
          name: InstSize
          desc: Memory size of a single RAM tile (in bytes).
          type: int
          default: 4096
          local: "false"
          expose: "true"
          name_top: SramCtrlMboxInstSize
        }
        {
          name: NumRamInst
          desc: Number of internal RAM instances. Must be the same as ceil(MemSizeRam / InstSize) .
          type: int
          default: 1
          local: "false"
          expose: "true"
          name_top: SramCtrlMboxNumRamInst
        }
        {
          name: InstrExec
          desc: Support execution from SRAM
          type: bit
          default: "0"
          local: "false"
          expose: "true"
          name_top: SramCtrlMboxInstrExec
        }
        {
          name: NumPrinceRoundsHalf
          desc: Number of PRINCE half rounds for the SRAM scrambling feature
          type: int
          default: "3"
          local: "false"
          expose: "true"
          name_top: SramCtrlMboxNumPrinceRoundsHalf
        }
        {
          name: UseOTIntegErr
          desc: When set to 0, use Rivos error logging
          type: bit
          default: "1"
          local: "false"
          expose: "true"
          name_top: SramCtrlMboxUseOTIntegErr
        }
        {
          name: UseCompiledRam
          desc: When set to 1, use compiled SRAM macros
          type: bit
          default: "1"
          local: "false"
          expose: "true"
          name_top: SramCtrlMboxUseCompiledRam
        }
        {
          name: FlopRamOutput
          desc: Flop the output s
          type: bit
          default: "1"
          local: "false"
          expose: "true"
          name_top: SramCtrlMboxFlopRamOutput
        }
      ]
      inter_signal_list:
      [
        {
          name: sram_otp_key
          struct: sram_otp_key
          package: otp_ctrl_pkg
          type: req_rsp
          act: req
          width: 1
          inst_name: sram_ctrl_mbox
          index: -1
        }
        {
          name: cfg
          struct: ram_1p_cfg
          package: prim_ram_1p_pkg
          type: uni
          act: rcv
          width:
          {
            name: NumRamInst
            desc: Number of internal RAM instances. Must be the same as ceil(MemSizeRam / InstSize) .
            param_type: int
            unpacked_dimensions: null
            default: 1
            local: false
            expose: true
            name_top: SramCtrlMboxNumRamInst
          }
          default: "'0"
          inst_name: sram_ctrl_mbox
          external: true
          top_signame: sram_ctrl_mbox_ram_1p_cfg
          conn_type: false
          index: -1
        }
        {
          name: cfg_rsp
          struct: ram_1p_cfg_rsp
          package: prim_ram_1p_pkg
          type: uni
          act: req
          width:
          {
            name: NumRamInst
            desc: Number of internal RAM instances. Must be the same as ceil(MemSizeRam / InstSize) .
            param_type: int
            unpacked_dimensions: null
            default: 1
            local: false
            expose: true
            name_top: SramCtrlMboxNumRamInst
          }
          default: "'0"
          inst_name: sram_ctrl_mbox
          external: true
          top_signame: sram_ctrl_mbox_ram_1p_cfg_rsp
          conn_type: false
          index: -1
        }
        {
          name: lc_escalate_en
          struct: lc_tx
          package: lc_ctrl_pkg
          type: uni
          act: rcv
          width: 1
          default: lc_ctrl_pkg::Off
          inst_name: sram_ctrl_mbox
          top_signame: soc_proxy_lc_escalate_en
          index: -1
        }
        {
          name: lc_hw_debug_en
          struct: lc_tx
          package: lc_ctrl_pkg
          type: uni
          act: rcv
          width: 1
          default: lc_ctrl_pkg::Off
          inst_name: sram_ctrl_mbox
          top_signame: soc_proxy_lc_hw_debug_en
          index: -1
        }
        {
          name: otp_en_sram_ifetch
          struct: mubi8
          package: prim_mubi_pkg
          type: uni
          act: rcv
          width: 1
          default: prim_mubi_pkg::MuBi8False
          inst_name: sram_ctrl_mbox
          index: -1
        }
        {
          name: sram_error_record_uncor_err
          desc: SRAM Error injection reporting
          struct: logic
          type: uni
          act: req
          width: 1
          inst_name: sram_ctrl_mbox
          index: -1
        }
        {
          name: sram_error_record_corr_err
          desc: SRAM Error injection reporting
          struct: logic
          type: uni
          act: req
          width: 1
          inst_name: sram_ctrl_mbox
          index: -1
        }
        {
          name: sram_error_record_err_addr
          desc: SRAM Error injection reporting
          struct: logic [top_pkg::TL_AW-1:0]
          type: uni
          act: req
          width: 1
          inst_name: sram_ctrl_mbox
          index: -1
        }
        {
          name: regs_tl
          struct: tl
          package: tlul_pkg
          type: req_rsp
          act: rsp
          width: 1
          inst_name: sram_ctrl_mbox
          default: ""
          end_idx: -1
          top_signame: sram_ctrl_mbox_regs_tl
          index: -1
        }
        {
          name: ram_tl
          struct: tl
          package: tlul_pkg
          type: req_rsp
          act: rsp
          width: 1
          inst_name: sram_ctrl_mbox
          default: ""
          end_idx: -1
          top_signame: sram_ctrl_mbox_ram_tl
          index: -1
        }
      ]
      generate_dif: true
    }
    {
      name: dma
      type: dma
      clock_srcs:
      {
        clk_i: ext_main
      }
      clock_group: infra
      reset_connections:
      {
        rst_ni:
        {
          name: ext_rst_main
          domain: "0"
        }
      }
      outgoing_alert: pwc
      clock_connections:
      {
        clk_i: clk_ext_main_i
      }
      domain:
      [
        "0"
      ]
      param_decl: {}
      memory: {}
      param_list:
      [
        {
          name: EnableDataIntgGen
          desc: Compute integrity bits for A channel data on all TL-UL host ports
          type: bit
          default: 1'b1
          local: "false"
          expose: "true"
          name_top: DmaEnableDataIntgGen
        }
        {
          name: EnableRspDataIntgCheck
          desc: Enable integrity checks on the response TL-UL D channel
          type: bit
          default: 1'b1
          local: "false"
          expose: "true"
          name_top: DmaEnableRspDataIntgCheck
        }
        {
          name: TlUserRsvd
          desc: Value of `rsvd` field in A channel of all TL-UL host ports
          type: logic [tlul_pkg::RsvdWidth-1:0]
          default: "'0"
          local: "false"
          expose: "true"
          name_top: DmaTlUserRsvd
        }
        {
          name: SysRacl
          desc: Value of `racl_vec` field in `sys` output
          type: logic [dma_pkg::SYS_RACL_WIDTH-1:0]
          default: "'0"
          local: "false"
          expose: "true"
          name_top: DmaSysRacl
        }
        {
          name: OtAgentId
          desc: OT Agent ID
          type: int unsigned
          default: "0"
          local: "false"
          expose: "true"
          name_top: DmaOtAgentId
        }
      ]
      inter_signal_list:
      [
        {
          name: lsio_trigger
          struct: lsio_trigger
          package: dma_pkg
          type: uni
          act: rcv
          width: 1
          inst_name: dma
          default: ""
          end_idx: -1
          top_type: broadcast
          top_signame: dma_lsio_trigger
          index: -1
        }
        {
          name: sys
          struct: sys
          package: dma_pkg
          type: req_rsp
          act: req
          width: 1
          inst_name: dma
          default: ""
          external: true
          top_signame: dma_sys
          conn_type: false
          index: -1
        }
        {
          name: ctn_tl_h2d
          desc: TL-UL host port for egress into CTN (request part), synchronous
          struct: tl_h2d
          package: tlul_pkg
          type: uni
          act: req
          width: 1
          inst_name: dma
          default: ""
          external: true
          top_signame: dma_ctn_tl_h2d
          conn_type: false
          index: -1
        }
        {
          name: ctn_tl_d2h
          desc: TL-UL host port for egress into CTN (response part), synchronous
          struct: tl_d2h
          package: tlul_pkg
          type: uni
          act: rcv
          width: 1
          inst_name: dma
          default: ""
          external: true
          top_signame: dma_ctn_tl_d2h
          conn_type: false
          index: -1
        }
        {
          name: host_tl_h
          struct: tl
          package: tlul_pkg
          type: req_rsp
          act: req
          width: 1
          inst_name: dma
          default: ""
          top_signame: pwc_main_tl_dma__host
          index: -1
        }
        {
          name: tl_d
          struct: tl
          package: tlul_pkg
          type: req_rsp
          act: rsp
          width: 1
          inst_name: dma
          default: ""
          end_idx: -1
          top_signame: dma_tl_d
          index: -1
        }
      ]
      base_addrs:
      {
        null:
        {
          hart: 0x22010000
        }
      }
      generate_dif: true
    }
    {
      name: mbx0
      type: mbx
      clock_srcs:
      {
        clk_i: ext_main
      }
      clock_group: infra
      reset_connections:
      {
        rst_ni:
        {
          name: ext_rst_main
          domain: "0"
        }
      }
      base_addrs:
      {
        core:
        {
          hart: 0x22000000
        }
        soc:
        {
          soc_mbx: 0x01465000
        }
      }
      outgoing_alert: pwc
      clock_connections:
      {
        clk_i: clk_ext_main_i
      }
      domain:
      [
        "0"
      ]
      param_decl: {}
      param_list: []
      inter_signal_list:
      [
        {
          name: doe_intr_support
          struct: logic
          type: uni
          act: req
          width: 1
          default: 1'b0
          inst_name: mbx0
          index: -1
        }
        {
          name: doe_intr_en
          struct: logic
          type: uni
          act: req
          width: 1
          default: 1'b0
          inst_name: mbx0
          index: -1
        }
        {
          name: doe_intr
          struct: logic
          type: uni
          act: req
          width: 1
          default: 1'b0
          inst_name: mbx0
          index: -1
        }
        {
          name: doe_async_msg_support
          struct: logic
          type: uni
          act: req
          width: 1
          default: 1'b0
          inst_name: mbx0
          index: -1
        }
        {
          name: sram_tl_h
          struct: tl
          package: tlul_pkg
          type: req_rsp
          act: req
          width: 1
          inst_name: mbx0
          default: ""
          top_signame: pwc_main_tl_mbx0__sram
          index: -1
        }
        {
          name: core_tl_d
          struct: tl
          package: tlul_pkg
          type: req_rsp
          act: rsp
          width: 1
          inst_name: mbx0
          default: ""
          end_idx: -1
          top_signame: mbx0_core_tl_d
          index: -1
        }
        {
          name: soc_tl_d
          struct: tl
          package: tlul_pkg
          type: req_rsp
          act: rsp
          width: 1
          inst_name: mbx0
          default: ""
          end_idx: -1
          top_signame: mbx0_soc_tl_d
          index: -1
        }
      ]
      generate_dif: true
    }
    {
      name: mbx1
      type: mbx
      clock_srcs:
      {
        clk_i: ext_main
      }
      clock_group: infra
      reset_connections:
      {
        rst_ni:
        {
          name: ext_rst_main
          domain: "0"
        }
      }
      base_addrs:
      {
        core:
        {
          hart: 0x22000100
        }
        soc:
        {
          soc_mbx: 0x01465100
        }
      }
      outgoing_alert: pwc
      clock_connections:
      {
        clk_i: clk_ext_main_i
      }
      domain:
      [
        "0"
      ]
      param_decl: {}
      param_list: []
      inter_signal_list:
      [
        {
          name: doe_intr_support
          struct: logic
          type: uni
          act: req
          width: 1
          default: 1'b0
          inst_name: mbx1
          index: -1
        }
        {
          name: doe_intr_en
          struct: logic
          type: uni
          act: req
          width: 1
          default: 1'b0
          inst_name: mbx1
          index: -1
        }
        {
          name: doe_intr
          struct: logic
          type: uni
          act: req
          width: 1
          default: 1'b0
          inst_name: mbx1
          index: -1
        }
        {
          name: doe_async_msg_support
          struct: logic
          type: uni
          act: req
          width: 1
          default: 1'b0
          inst_name: mbx1
          index: -1
        }
        {
          name: sram_tl_h
          struct: tl
          package: tlul_pkg
          type: req_rsp
          act: req
          width: 1
          inst_name: mbx1
          default: ""
          top_signame: pwc_main_tl_mbx1__sram
          index: -1
        }
        {
          name: core_tl_d
          struct: tl
          package: tlul_pkg
          type: req_rsp
          act: rsp
          width: 1
          inst_name: mbx1
          default: ""
          end_idx: -1
          top_signame: mbx1_core_tl_d
          index: -1
        }
        {
          name: soc_tl_d
          struct: tl
          package: tlul_pkg
          type: req_rsp
          act: rsp
          width: 1
          inst_name: mbx1
          default: ""
          end_idx: -1
          top_signame: mbx1_soc_tl_d
          index: -1
        }
      ]
      generate_dif: true
    }
    {
      name: mbx2
      type: mbx
      clock_srcs:
      {
        clk_i: ext_main
      }
      clock_group: infra
      reset_connections:
      {
        rst_ni:
        {
          name: ext_rst_main
          domain: "0"
        }
      }
      base_addrs:
      {
        core:
        {
          hart: 0x22000200
        }
        soc:
        {
          soc_mbx: 0x01465200
        }
      }
      outgoing_alert: pwc
      clock_connections:
      {
        clk_i: clk_ext_main_i
      }
      domain:
      [
        "0"
      ]
      param_decl: {}
      param_list: []
      inter_signal_list:
      [
        {
          name: doe_intr_support
          struct: logic
          type: uni
          act: req
          width: 1
          default: 1'b0
          inst_name: mbx2
          index: -1
        }
        {
          name: doe_intr_en
          struct: logic
          type: uni
          act: req
          width: 1
          default: 1'b0
          inst_name: mbx2
          index: -1
        }
        {
          name: doe_intr
          struct: logic
          type: uni
          act: req
          width: 1
          default: 1'b0
          inst_name: mbx2
          index: -1
        }
        {
          name: doe_async_msg_support
          struct: logic
          type: uni
          act: req
          width: 1
          default: 1'b0
          inst_name: mbx2
          index: -1
        }
        {
          name: sram_tl_h
          struct: tl
          package: tlul_pkg
          type: req_rsp
          act: req
          width: 1
          inst_name: mbx2
          default: ""
          top_signame: pwc_main_tl_mbx2__sram
          index: -1
        }
        {
          name: core_tl_d
          struct: tl
          package: tlul_pkg
          type: req_rsp
          act: rsp
          width: 1
          inst_name: mbx2
          default: ""
          end_idx: -1
          top_signame: mbx2_core_tl_d
          index: -1
        }
        {
          name: soc_tl_d
          struct: tl
          package: tlul_pkg
          type: req_rsp
          act: rsp
          width: 1
          inst_name: mbx2
          default: ""
          end_idx: -1
          top_signame: mbx2_soc_tl_d
          index: -1
        }
      ]
      generate_dif: true
    }
    {
      name: mbx3
      type: mbx
      clock_srcs:
      {
        clk_i: ext_main
      }
      clock_group: infra
      reset_connections:
      {
        rst_ni:
        {
          name: ext_rst_main
          domain: "0"
        }
      }
      base_addrs:
      {
        core:
        {
          hart: 0x22000300
        }
        soc:
        {
          soc_mbx: 0x01465300
        }
      }
      outgoing_alert: pwc
      clock_connections:
      {
        clk_i: clk_ext_main_i
      }
      domain:
      [
        "0"
      ]
      param_decl: {}
      param_list: []
      inter_signal_list:
      [
        {
          name: doe_intr_support
          struct: logic
          type: uni
          act: req
          width: 1
          default: 1'b0
          inst_name: mbx3
          index: -1
        }
        {
          name: doe_intr_en
          struct: logic
          type: uni
          act: req
          width: 1
          default: 1'b0
          inst_name: mbx3
          index: -1
        }
        {
          name: doe_intr
          struct: logic
          type: uni
          act: req
          width: 1
          default: 1'b0
          inst_name: mbx3
          index: -1
        }
        {
          name: doe_async_msg_support
          struct: logic
          type: uni
          act: req
          width: 1
          default: 1'b0
          inst_name: mbx3
          index: -1
        }
        {
          name: sram_tl_h
          struct: tl
          package: tlul_pkg
          type: req_rsp
          act: req
          width: 1
          inst_name: mbx3
          default: ""
          top_signame: pwc_main_tl_mbx3__sram
          index: -1
        }
        {
          name: core_tl_d
          struct: tl
          package: tlul_pkg
          type: req_rsp
          act: rsp
          width: 1
          inst_name: mbx3
          default: ""
          end_idx: -1
          top_signame: mbx3_core_tl_d
          index: -1
        }
        {
          name: soc_tl_d
          struct: tl
          package: tlul_pkg
          type: req_rsp
          act: rsp
          width: 1
          inst_name: mbx3
          default: ""
          end_idx: -1
          top_signame: mbx3_soc_tl_d
          index: -1
        }
      ]
      generate_dif: true
    }
    {
      name: mbx4
      type: mbx
      clock_srcs:
      {
        clk_i: ext_main
      }
      clock_group: infra
      reset_connections:
      {
        rst_ni:
        {
          name: ext_rst_main
          domain: "0"
        }
      }
      base_addrs:
      {
        core:
        {
          hart: 0x22000400
        }
        soc:
        {
          soc_mbx: 0x01465400
        }
      }
      outgoing_alert: pwc
      clock_connections:
      {
        clk_i: clk_ext_main_i
      }
      domain:
      [
        "0"
      ]
      param_decl: {}
      param_list: []
      inter_signal_list:
      [
        {
          name: doe_intr_support
          struct: logic
          type: uni
          act: req
          width: 1
          default: 1'b0
          inst_name: mbx4
          index: -1
        }
        {
          name: doe_intr_en
          struct: logic
          type: uni
          act: req
          width: 1
          default: 1'b0
          inst_name: mbx4
          index: -1
        }
        {
          name: doe_intr
          struct: logic
          type: uni
          act: req
          width: 1
          default: 1'b0
          inst_name: mbx4
          index: -1
        }
        {
          name: doe_async_msg_support
          struct: logic
          type: uni
          act: req
          width: 1
          default: 1'b0
          inst_name: mbx4
          index: -1
        }
        {
          name: sram_tl_h
          struct: tl
          package: tlul_pkg
          type: req_rsp
          act: req
          width: 1
          inst_name: mbx4
          default: ""
          top_signame: pwc_main_tl_mbx4__sram
          index: -1
        }
        {
          name: core_tl_d
          struct: tl
          package: tlul_pkg
          type: req_rsp
          act: rsp
          width: 1
          inst_name: mbx4
          default: ""
          end_idx: -1
          top_signame: mbx4_core_tl_d
          index: -1
        }
        {
          name: soc_tl_d
          struct: tl
          package: tlul_pkg
          type: req_rsp
          act: rsp
          width: 1
          inst_name: mbx4
          default: ""
          end_idx: -1
          top_signame: mbx4_soc_tl_d
          index: -1
        }
      ]
      generate_dif: true
    }
    {
      name: mbx5
      type: mbx
      clock_srcs:
      {
        clk_i: ext_main
      }
      clock_group: infra
      reset_connections:
      {
        rst_ni:
        {
          name: ext_rst_main
          domain: "0"
        }
      }
      base_addrs:
      {
        core:
        {
          hart: 0x22000500
        }
        soc:
        {
          soc_mbx: 0x01465500
        }
      }
      outgoing_alert: pwc
      clock_connections:
      {
        clk_i: clk_ext_main_i
      }
      domain:
      [
        "0"
      ]
      param_decl: {}
      param_list: []
      inter_signal_list:
      [
        {
          name: doe_intr_support
          struct: logic
          type: uni
          act: req
          width: 1
          default: 1'b0
          inst_name: mbx5
          index: -1
        }
        {
          name: doe_intr_en
          struct: logic
          type: uni
          act: req
          width: 1
          default: 1'b0
          inst_name: mbx5
          index: -1
        }
        {
          name: doe_intr
          struct: logic
          type: uni
          act: req
          width: 1
          default: 1'b0
          inst_name: mbx5
          index: -1
        }
        {
          name: doe_async_msg_support
          struct: logic
          type: uni
          act: req
          width: 1
          default: 1'b0
          inst_name: mbx5
          index: -1
        }
        {
          name: sram_tl_h
          struct: tl
          package: tlul_pkg
          type: req_rsp
          act: req
          width: 1
          inst_name: mbx5
          default: ""
          top_signame: pwc_main_tl_mbx5__sram
          index: -1
        }
        {
          name: core_tl_d
          struct: tl
          package: tlul_pkg
          type: req_rsp
          act: rsp
          width: 1
          inst_name: mbx5
          default: ""
          end_idx: -1
          top_signame: mbx5_core_tl_d
          index: -1
        }
        {
          name: soc_tl_d
          struct: tl
          package: tlul_pkg
          type: req_rsp
          act: rsp
          width: 1
          inst_name: mbx5
          default: ""
          end_idx: -1
          top_signame: mbx5_soc_tl_d
          index: -1
        }
      ]
      generate_dif: true
    }
    {
      name: rv_core_ibex
      type: rv_core_ibex
      param_decl:
      {
        PMPEnable: "1"
        PMPGranularity: "0"
        PMPNumRegions: "16"
        MHPMCounterNum: "10"
        MHPMCounterWidth: "32"
        RV32E: "0"
        RV32M: ibex_pkg::RV32MSingleCycle
        RV32B: ibex_pkg::RV32BOTEarlGrey
        RegFile: ibex_pkg::RegFileFF
        BranchTargetALU: "1"
        WritebackStage: "1"
        ICache: "1"
        ICacheECC: "1"
        ICacheScramble: "1"
        BranchPredictor: "0"
        DbgTriggerEn: "1"
        DbgHwBreakNum: "4"
        SecureIbex: "1"
        DmHaltAddr: tl_main_pkg::ADDR_SPACE_RV_DM__MEM + dm::HaltAddress[31:0]
        DmExceptionAddr: tl_main_pkg::ADDR_SPACE_RV_DM__MEM + dm::ExceptionAddress[31:0]
        PipeLine: "0"
      }
      clock_srcs:
      {
        clk_i: ext_main
        clk_edn_i: ext_main
        clk_esc_i:
        {
          clock: ext_io_div4
          group: secure
        }
        clk_otp_i:
        {
          clock: ext_io_div4
          group: secure
        }
      }
      clock_group: infra
      reset_connections:
      {
        rst_ni:
        {
          name: ext_rst_main
          domain: "0"
        }
        rst_edn_ni:
        {
          name: ext_rst_main
          domain: "0"
        }
        rst_esc_ni:
        {
          name: ext_rst_io_div4
          domain: "0"
        }
        rst_otp_ni:
        {
          name: ext_rst_io_div4
          domain: "0"
        }
      }
      outgoing_alert: pwc
      clock_connections:
      {
        clk_i: clk_ext_main_i
        clk_edn_i: clk_ext_main_i
        clk_esc_i: clk_ext_io_div4_i
        clk_otp_i: clk_ext_io_div4_i
      }
      domain:
      [
        "0"
      ]
      memory: {}
      param_list:
      [
        {
          name: RndCnstLfsrSeed
          desc: Default seed of the PRNG used for random instructions.
          type: ibex_pkg::lfsr_seed_t
          randcount: 32
          randtype: data
          name_top: RndCnstRvCoreIbexLfsrSeed
          default: 0x93709238
          randwidth: 32
        }
        {
          name: RndCnstLfsrPerm
          desc: Permutation applied to the LFSR of the PRNG used for random instructions.
          type: ibex_pkg::lfsr_perm_t
          randcount: 32
          randtype: perm
          name_top: RndCnstRvCoreIbexLfsrPerm
          default: 0x92b5c7543b4429d21807fbfc9165788b27768ec5
          randwidth: 160
        }
        {
          name: RndCnstIbexKeyDefault
          desc: Default icache scrambling key
          type: logic [ibex_pkg::SCRAMBLE_KEY_W-1:0]
          randcount: 128
          randtype: data
          name_top: RndCnstRvCoreIbexIbexKeyDefault
          default: 0x7669266cfd1f508ac4e1c5f6668afd03
          randwidth: 128
        }
        {
          name: RndCnstIbexNonceDefault
          desc: Default icache scrambling nonce
          type: logic [ibex_pkg::SCRAMBLE_NONCE_W-1:0]
          randcount: 64
          randtype: data
          name_top: RndCnstRvCoreIbexIbexNonceDefault
          default: 0x4dc05df9ec203b9e
          randwidth: 64
        }
        {
          name: NEscalationSeverities
          desc: Number of escalation severities
          type: int unsigned
          default: "4"
          local: "true"
          expose: "true"
          name_top: RvCoreIbexNEscalationSeverities
        }
        {
          name: WidthPingCounter
          desc: Width of the ping counter
          type: int unsigned
          default: "16"
          local: "true"
          expose: "true"
          name_top: RvCoreIbexWidthPingCounter
        }
        {
          name: PMPEnable
          desc: Enable PMP
          type: bit
          default: "1"
          local: "false"
          expose: "true"
          name_top: RvCoreIbexPMPEnable
        }
        {
          name: PMPGranularity
          desc: PMP Granularity
          type: int unsigned
          default: "0"
          local: "false"
          expose: "true"
          name_top: RvCoreIbexPMPGranularity
        }
        {
          name: PMPNumRegions
          desc: PMP number of regions
          type: int unsigned
          default: "16"
          local: "false"
          expose: "true"
          name_top: RvCoreIbexPMPNumRegions
        }
        {
          name: MHPMCounterNum
          desc: "Number of the MHPM counter "
          type: int unsigned
          default: "10"
          local: "false"
          expose: "true"
          name_top: RvCoreIbexMHPMCounterNum
        }
        {
          name: MHPMCounterWidth
          desc: "Width of the MHPM Counter "
          type: int unsigned
          default: "32"
          local: "false"
          expose: "true"
          name_top: RvCoreIbexMHPMCounterWidth
        }
        {
          name: PMPRstCfg
          desc: Reset value of PMP config CSRs
          type: ibex_pkg::pmp_cfg_t
          unpacked_dimensions: "[16]"
          default: ibex_pkg::PmpCfgRst
          local: "false"
          expose: "true"
          name_top: RvCoreIbexPMPRstCfg
        }
        {
          name: PMPRstAddr
          desc: Reset value of PMP address CSRs
          type: logic [33:0]
          unpacked_dimensions: "[16]"
          default: ibex_pkg::PmpAddrRst
          local: "false"
          expose: "true"
          name_top: RvCoreIbexPMPRstAddr
        }
        {
          name: PMPRstMsecCfg
          desc: Reset value of MSECCFG CSR
          type: ibex_pkg::pmp_mseccfg_t
          default: ibex_pkg::PmpMseccfgRst
          local: "false"
          expose: "true"
          name_top: RvCoreIbexPMPRstMsecCfg
        }
        {
          name: RV32E
          desc: RV32E
          type: bit
          default: "0"
          local: "false"
          expose: "true"
          name_top: RvCoreIbexRV32E
        }
        {
          name: RV32M
          desc: RV32M
          type: ibex_pkg::rv32m_e
          default: ibex_pkg::RV32MSingleCycle
          local: "false"
          expose: "true"
          name_top: RvCoreIbexRV32M
        }
        {
          name: RV32B
          desc: RV32B
          type: ibex_pkg::rv32b_e
          default: ibex_pkg::RV32BOTEarlGrey
          local: "false"
          expose: "true"
          name_top: RvCoreIbexRV32B
        }
        {
          name: RegFile
          desc: Reg file
          type: ibex_pkg::regfile_e
          default: ibex_pkg::RegFileFF
          local: "false"
          expose: "true"
          name_top: RvCoreIbexRegFile
        }
        {
          name: BranchTargetALU
          desc: Branch target ALU
          type: bit
          default: "1"
          local: "false"
          expose: "true"
          name_top: RvCoreIbexBranchTargetALU
        }
        {
          name: WritebackStage
          desc: Write back stage
          type: bit
          default: "1"
          local: "false"
          expose: "true"
          name_top: RvCoreIbexWritebackStage
        }
        {
          name: ICache
          desc: Instruction cache
          type: bit
          default: "1"
          local: "false"
          expose: "true"
          name_top: RvCoreIbexICache
        }
        {
          name: ICacheECC
          desc: Instruction cache ECC
          type: bit
          default: "1"
          local: "false"
          expose: "true"
          name_top: RvCoreIbexICacheECC
        }
        {
          name: ICacheScramble
          desc: Scramble instruction cach
          type: bit
          default: "1"
          local: "false"
          expose: "true"
          name_top: RvCoreIbexICacheScramble
        }
        {
          name: ICacheNWays
          desc: Number of instruction cache ways
          type: int unsigned
          default: 2
          local: "false"
          expose: "true"
          name_top: RvCoreIbexICacheNWays
        }
        {
          name: BranchPredictor
          desc: Branch predictor
          type: bit
          default: "0"
          local: "false"
          expose: "true"
          name_top: RvCoreIbexBranchPredictor
        }
        {
          name: DbgTriggerEn
          desc: Enable degug trigger
          type: bit
          default: "1"
          local: "false"
          expose: "true"
          name_top: RvCoreIbexDbgTriggerEn
        }
        {
          name: DbgHwBreakNum
          desc: Number of debug hardware break
          type: int
          default: "4"
          local: "false"
          expose: "true"
          name_top: RvCoreIbexDbgHwBreakNum
        }
        {
          name: SecureIbex
          desc: "Width of the MHPM Counter "
          type: bit
          default: "1"
          local: "false"
          expose: "true"
          name_top: RvCoreIbexSecureIbex
        }
        {
          name: DmBaseAddr
          desc: Base address of Debug Module
          type: int unsigned
          default: "437321728"
          local: "false"
          expose: "true"
          name_top: RvCoreIbexDmBaseAddr
        }
        {
          name: DmAddrMask
          desc: Adress mask of Debug Module
          type: int unsigned
          default: "4095"
          local: "false"
          expose: "true"
          name_top: RvCoreIbexDmAddrMask
        }
        {
          name: DmHaltAddr
          desc: Halt address
          type: int unsigned
          default: tl_main_pkg::ADDR_SPACE_RV_DM__MEM + dm::HaltAddress[31:0]
          local: "false"
          expose: "true"
          name_top: RvCoreIbexDmHaltAddr
        }
        {
          name: DmExceptionAddr
          desc: Exception address
          type: int unsigned
          default: tl_main_pkg::ADDR_SPACE_RV_DM__MEM + dm::ExceptionAddress[31:0]
          local: "false"
          expose: "true"
          name_top: RvCoreIbexDmExceptionAddr
        }
        {
          name: PipeLine
          desc: Pipe line
          type: bit
          default: "0"
          local: "false"
          expose: "true"
          name_top: RvCoreIbexPipeLine
        }
      ]
      inter_signal_list:
      [
        {
          name: rst_cpu_n
          struct: logic
          type: uni
          act: req
          width: 1
          inst_name: rv_core_ibex
          index: -1
        }
        {
          name: ram_cfg_icache_tag
          struct: ram_1p_cfg
          package: prim_ram_1p_pkg
          type: uni
          act: rcv
          width: 1
          inst_name: rv_core_ibex
          index: -1
        }
        {
          name: ram_cfg_rsp_icache_tag
          struct: ram_1p_cfg_rsp
          package: prim_ram_1p_pkg
          type: uni
          act: req
          width:
          {
            name: ICacheNWays
            desc: Number of instruction cache ways
            param_type: int unsigned
            unpacked_dimensions: null
            default: 2
            local: false
            expose: true
            name_top: RvCoreIbexICacheNWays
          }
          inst_name: rv_core_ibex
          index: -1
        }
        {
          name: ram_cfg_icache_data
          struct: ram_1p_cfg
          package: prim_ram_1p_pkg
          type: uni
          act: rcv
          width: 1
          inst_name: rv_core_ibex
          index: -1
        }
        {
          name: ram_cfg_rsp_icache_data
          struct: ram_1p_cfg_rsp
          package: prim_ram_1p_pkg
          type: uni
          act: req
          width:
          {
            name: ICacheNWays
            desc: Number of instruction cache ways
            param_type: int unsigned
            unpacked_dimensions: null
            default: 2
            local: false
            expose: true
            name_top: RvCoreIbexICacheNWays
          }
          inst_name: rv_core_ibex
          index: -1
        }
        {
          name: hart_id
          struct: logic
          type: uni
          act: rcv
          width: 32
          inst_name: rv_core_ibex
          default: ""
          package: ""
          top_signame: rv_core_ibex_hart_id
          index: -1
        }
        {
          name: boot_addr
          struct: logic
          type: uni
          act: rcv
          width: 32
          inst_name: rv_core_ibex
          default: ""
          package: ""
          external: true
          top_signame: rv_boot_addr
          conn_type: false
          index: -1
        }
        {
          name: irq_software
          struct: logic
          type: uni
          act: rcv
          width: 1
          inst_name: rv_core_ibex
          default: ""
          package: ""
          top_signame: rv_plic_msip
          index: -1
        }
        {
          name: irq_timer
          struct: logic
          type: uni
          act: rcv
          width: 1
          inst_name: rv_core_ibex
          default: ""
          package: ""
          top_signame: rv_core_ibex_irq_timer
          index: -1
        }
        {
          name: irq_external
          struct: logic
          type: uni
          act: rcv
          width: 1
          inst_name: rv_core_ibex
          default: ""
          package: ""
          top_signame: rv_plic_irq
          index: -1
        }
        {
          name: esc_tx
          struct: esc_tx
          package: prim_esc_pkg
          type: uni
          act: rcv
          width: 1
          inst_name: rv_core_ibex
          default: ""
          external: true
          top_signame: rv_core_esc_tx
          conn_type: false
          index: -1
        }
        {
          name: esc_rx
          struct: esc_rx
          package: prim_esc_pkg
          type: uni
          act: req
          width: 1
          inst_name: rv_core_ibex
          default: ""
          external: true
          top_signame: rv_core_esc_rx
          conn_type: false
          index: -1
        }
        {
          name: debug_req
          struct: logic
          type: uni
          act: rcv
          width: 1
          inst_name: rv_core_ibex
          default: ""
          package: ""
          top_signame: rv_dm_debug_req
          index: -1
        }
        {
          name: crash_dump
          struct: cpu_crash_dump
          package: rv_core_ibex_pkg
          type: uni
          act: req
          width: 1
          inst_name: rv_core_ibex
          index: -1
        }
        {
          name: lc_cpu_en
          struct: lc_tx
          package: lc_ctrl_pkg
          type: uni
          act: rcv
          width: 1
          inst_name: rv_core_ibex
          default: ""
          external: true
          top_signame: rv_cpu_en
          conn_type: false
          index: -1
        }
        {
          name: pwrmgr_cpu_en
          struct: lc_tx
          package: lc_ctrl_pkg
          type: uni
          act: rcv
          width: 1
          inst_name: rv_core_ibex
          index: -1
        }
        {
          name: pwrmgr
          struct: cpu_pwrmgr
          package: rv_core_ibex_pkg
          type: uni
          act: req
          width: 1
          inst_name: rv_core_ibex
          index: -1
        }
        {
          name: nmi_wdog
          struct: logic
          type: uni
          act: rcv
          width: 1
          inst_name: rv_core_ibex
          default: ""
          package: ""
          top_signame: aon_timer_aon_nmi_wdog_timer_bark
          index: -1
        }
        {
          name: edn
          struct: edn
          package: edn_pkg
          type: req_rsp
          act: req
          width: 1
          inst_name: rv_core_ibex
          index: -1
        }
        {
          name: icache_otp_key
          struct: sram_otp_key
          package: otp_ctrl_pkg
          type: req_rsp
          act: req
          width: 1
          inst_name: rv_core_ibex
          index: -1
        }
        {
          name: fpga_info
          struct: logic
          type: uni
          act: rcv
          width: 32
          inst_name: rv_core_ibex
          default: ""
          package: ""
          external: true
          top_signame: fpga_info
          conn_type: false
          index: -1
        }
        {
          name: corei_tl_h
          struct: tl
          package: tlul_pkg
          type: req_rsp
          act: req
          width: 1
          inst_name: rv_core_ibex
          default: ""
          top_signame: pwc_main_tl_rv_core_ibex__corei
          index: -1
        }
        {
          name: cored_tl_h
          struct: tl
          package: tlul_pkg
          type: req_rsp
          act: req
          width: 1
          inst_name: rv_core_ibex
          default: ""
          top_signame: pwc_main_tl_rv_core_ibex__cored
          index: -1
        }
        {
          name: cfg_tl_d
          struct: tl
          package: tlul_pkg
          type: req_rsp
          act: rsp
          width: 1
          inst_name: rv_core_ibex
          default: ""
          end_idx: -1
          top_signame: rv_core_ibex_cfg_tl_d
          index: -1
        }
      ]
      base_addrs:
      {
        cfg:
        {
          hart: 0x211f0000
        }
      }
      generate_dif: true
    }
  ]
  memory: []
  port:
  [
    {}
  ]
  inter_module:
  {
    connect:
    {
      aon_timer_aon.nmi_wdog_timer_bark:
      [
        rv_core_ibex.nmi_wdog
      ]
      dma.lsio_trigger:
      [
        soc_proxy.dma_lsio_trigger
      ]
      rv_plic.msip:
      [
        rv_core_ibex.irq_software
      ]
      rv_plic.irq:
      [
        rv_core_ibex.irq_external
      ]
      rv_dm.debug_req:
      [
        rv_core_ibex.debug_req
      ]
      "soc_proxy.lc_hw_debug_en'":
      [
        rv_dm.lc_hw_debug_en
        sram_ctrl_ret_aon.lc_hw_debug_en
        sram_ctrl_mbox.lc_hw_debug_en
        sram_ctrl_main.lc_hw_debug_en
      ]
      "soc_proxy.lc_escalate_en'":
      [
        rv_dm.lc_escalate_en
        sram_ctrl_ret_aon.lc_escalate_en
        sram_ctrl_mbox.lc_escalate_en
        sram_ctrl_main.lc_escalate_en
        aon_timer_aon.lc_escalate_en
      ]
      sram_ctrl_main.otp_en_sram_ifetch:
      [
        soc_proxy.mubi8_true
      ]
      pwc_main.tl_rv_core_ibex__corei:
      [
        rv_core_ibex.corei_tl_h
      ]
      pwc_main.tl_rv_core_ibex__cored:
      [
        rv_core_ibex.cored_tl_h
      ]
      pwc_main.tl_rv_dm__sba:
      [
        rv_dm.sba_tl_h
      ]
      rv_dm.regs_tl_d:
      [
        pwc_main.tl_rv_dm__regs
      ]
      rv_dm.mem_tl_d:
      [
        pwc_main.tl_rv_dm__mem
      ]
      pwc_main.tl_pwc_peri:
      [
        pwc_peri.tl_pwc_main
      ]
      soc_proxy.core_tl:
      [
        pwc_main.tl_soc_proxy__core
      ]
      soc_proxy.ctn_tl:
      [
        pwc_main.tl_soc_proxy__ctn
      ]
      rv_plic.tl:
      [
        pwc_main.tl_rv_plic
      ]
      rv_core_ibex.cfg_tl_d:
      [
        pwc_main.tl_rv_core_ibex__cfg
      ]
      sram_ctrl_main.regs_tl:
      [
        pwc_main.tl_sram_ctrl_main__regs
      ]
      sram_ctrl_main.ram_tl:
      [
        pwc_main.tl_sram_ctrl_main__ram
      ]
      sram_ctrl_mbox.regs_tl:
      [
        pwc_main.tl_sram_ctrl_mbox__regs
      ]
      sram_ctrl_mbox.ram_tl:
      [
        pwc_main.tl_sram_ctrl_mbox__ram
      ]
      dma.tl_d:
      [
        pwc_main.tl_dma
      ]
      pwc_main.tl_dma__host:
      [
        dma.host_tl_h
      ]
      mbx0.core_tl_d:
      [
        pwc_main.tl_mbx0__core
      ]
      pwc_main.tl_mbx0__sram:
      [
        mbx0.sram_tl_h
      ]
      mbx1.core_tl_d:
      [
        pwc_main.tl_mbx1__core
      ]
      pwc_main.tl_mbx1__sram:
      [
        mbx1.sram_tl_h
      ]
      mbx2.core_tl_d:
      [
        pwc_main.tl_mbx2__core
      ]
      pwc_main.tl_mbx2__sram:
      [
        mbx2.sram_tl_h
      ]
      mbx3.core_tl_d:
      [
        pwc_main.tl_mbx3__core
      ]
      pwc_main.tl_mbx3__sram:
      [
        mbx3.sram_tl_h
      ]
      mbx4.core_tl_d:
      [
        pwc_main.tl_mbx4__core
      ]
      pwc_main.tl_mbx4__sram:
      [
        mbx4.sram_tl_h
      ]
      mbx5.core_tl_d:
      [
        pwc_main.tl_mbx5__core
      ]
      pwc_main.tl_mbx5__sram:
      [
        mbx5.sram_tl_h
      ]
      gpio.tl:
      [
        pwc_peri.tl_gpio
      ]
      rv_timer.tl:
      [
        pwc_peri.tl_rv_timer
      ]
      sram_ctrl_ret_aon.regs_tl:
      [
        pwc_peri.tl_sram_ctrl_ret_aon__regs
      ]
      sram_ctrl_ret_aon.ram_tl:
      [
        pwc_peri.tl_sram_ctrl_ret_aon__ram
      ]
      aon_timer_aon.tl:
      [
        pwc_peri.tl_aon_timer_aon
      ]
      mbx0.soc_tl_d:
      [
        pwc_mbx.tl_mbx0__soc
      ]
      mbx1.soc_tl_d:
      [
        pwc_mbx.tl_mbx1__soc
      ]
      mbx2.soc_tl_d:
      [
        pwc_mbx.tl_mbx2__soc
      ]
      mbx3.soc_tl_d:
      [
        pwc_mbx.tl_mbx3__soc
      ]
      mbx4.soc_tl_d:
      [
        pwc_mbx.tl_mbx4__soc
      ]
      mbx5.soc_tl_d:
      [
        pwc_mbx.tl_mbx5__soc
      ]
    }
    top:
    [
      rv_core_ibex.irq_timer
      rv_core_ibex.hart_id
    ]
    external:
    {
      dma.sys: dma_sys
      dma.ctn_tl_h2d: dma_ctn_tl_h2d
      dma.ctn_tl_d2h: dma_ctn_tl_d2h
      pwc_mbx.tl_pwc_mbx: mbx_tl
      rv_dm.next_dm_addr: rv_dm_next_dm_addr
      rv_dm.dbg_tl_d: rv_dm_dbg
      rv_core_ibex.fpga_info: fpga_info
      soc_proxy.ctn_tl_h2d: ctn_tl_h2d
      rv_core_ibex.boot_addr: rv_boot_addr
      rv_core_ibex.lc_cpu_en: rv_cpu_en
      rv_core_ibex.esc_rx: rv_core_esc_rx
      rv_core_ibex.esc_tx: rv_core_esc_tx
      soc_proxy.ctn_tl_d2h: ctn_tl_d2h
      soc_proxy.lc_hw_debug_en_ext: lc_hw_debug_en_ext
      soc_proxy.lc_escalate_en_ext: lc_escalate_en_ext
      soc_proxy.soc_lsio_trigger: soc_lsio_trigger
      rv_dm.lc_check_byp_en: lc_check_byp_en
      sram_ctrl_ret_aon.cfg: sram_ctrl_ret_aon_ram_1p_cfg
      sram_ctrl_ret_aon.cfg_rsp: sram_ctrl_ret_aon_ram_1p_cfg_rsp
      sram_ctrl_main.cfg: sram_ctrl_main_ram_1p_cfg
      sram_ctrl_main.cfg_rsp: sram_ctrl_main_ram_1p_cfg_rsp
      sram_ctrl_mbox.cfg: sram_ctrl_mbox_ram_1p_cfg
      sram_ctrl_mbox.cfg_rsp: sram_ctrl_mbox_ram_1p_cfg_rsp
    }
  }
  xbar:
  [
    {
      name: pwc_main
      clock_srcs:
      {
        clk_main_i: ext_main
        clk_fixed_i: ext_io_div4
      }
      clock_group: infra
      reset: rst_main_ni
      reset_connections:
      {
        rst_main_ni:
        {
          name: ext_rst_main
          domain: "0"
        }
        rst_fixed_ni:
        {
          name: ext_rst_io_div4
          domain: "0"
        }
      }
      clock_connections:
      {
        clk_main_i: clk_ext_main_i
        clk_fixed_i: clk_ext_io_div4_i
      }
      domain:
      [
        "0"
      ]
      connections:
      {
        rv_core_ibex.corei:
        [
          rv_dm.mem
          sram_ctrl_main.ram
          soc_proxy.ctn
        ]
        rv_core_ibex.cored:
        [
          rv_dm.mem
          rv_dm.regs
          sram_ctrl_main.ram
          pwc_peri
          rv_plic
          sram_ctrl_main.regs
          rv_core_ibex.cfg
          sram_ctrl_mbox.ram
          sram_ctrl_mbox.regs
          soc_proxy.ctn
          soc_proxy.core
          dma
          mbx0.core
          mbx1.core
          mbx2.core
          mbx3.core
          mbx4.core
          mbx5.core
        ]
        rv_dm.sba:
        [
          rv_dm.mem
          rv_dm.regs
          sram_ctrl_main.ram
          pwc_peri
          rv_plic
          sram_ctrl_main.regs
          rv_core_ibex.cfg
          sram_ctrl_mbox.ram
          sram_ctrl_mbox.regs
          soc_proxy.ctn
          soc_proxy.core
          dma
          mbx0.core
          mbx1.core
          mbx2.core
          mbx3.core
          mbx4.core
          mbx5.core
        ]
        dma.host:
        [
          sram_ctrl_main.ram
          sram_ctrl_mbox.ram
          soc_proxy.ctn
          pwc_peri
        ]
        mbx0.sram:
        [
          sram_ctrl_mbox.ram
        ]
        mbx1.sram:
        [
          sram_ctrl_mbox.ram
        ]
        mbx2.sram:
        [
          sram_ctrl_mbox.ram
        ]
        mbx3.sram:
        [
          sram_ctrl_mbox.ram
        ]
        mbx4.sram:
        [
          sram_ctrl_mbox.ram
        ]
        mbx5.sram:
        [
          sram_ctrl_mbox.ram
        ]
      }
      nodes:
      [
        {
          name: rv_core_ibex.corei
          type: host
          addr_space: hart
          clock: clk_main_i
          reset: rst_main_ni
          pipeline: false
          xbar: false
          stub: false
          inst_type: ""
          req_fifo_pass: true
          rsp_fifo_pass: true
        }
        {
          name: rv_core_ibex.cored
          type: host
          addr_space: hart
          clock: clk_main_i
          reset: rst_main_ni
          pipeline: false
          xbar: false
          stub: false
          inst_type: ""
          req_fifo_pass: true
          rsp_fifo_pass: true
        }
        {
          name: rv_dm.sba
          type: host
          addr_space: hart
          clock: clk_main_i
          reset: rst_main_ni
          req_fifo_pass: false
          rsp_fifo_pass: false
          xbar: false
          stub: false
          inst_type: ""
          pipeline: true
        }
        {
          name: rv_dm.regs
          type: device
          clock: clk_main_i
          reset: rst_main_ni
          req_fifo_pass: false
          rsp_fifo_pass: false
          inst_type: rv_dm
          addr_range:
          [
            {
              base_addrs:
              {
                hart: 0x21200000
              }
              size_byte: 0x10
            }
          ]
          xbar: false
          stub: false
          pipeline: true
        }
        {
          name: rv_dm.mem
          type: device
          clock: clk_main_i
          reset: rst_main_ni
          req_fifo_pass: false
          rsp_fifo_pass: false
          inst_type: rv_dm
          addr_range:
          [
            {
              base_addrs:
              {
                hart: 0x40000
              }
              size_byte: 0x1000
            }
          ]
          xbar: false
          stub: false
          pipeline: true
        }
        {
          name: pwc_peri
          type: device
          clock: clk_fixed_i
          reset: rst_fixed_ni
          req_fifo_pass: false
          rsp_fifo_pass: false
          xbar: true
          stub: false
          pipeline: true
          addr_space: hart
          addr_range:
          [
            {
              base_addrs:
              {
                hart: 0x30000000
              }
              size_byte: 0x800000
            }
          ]
        }
        {
          name: soc_proxy.core
          type: device
          clock: clk_main_i
          reset: rst_main_ni
          req_fifo_pass: false
          rsp_fifo_pass: false
          inst_type: soc_proxy
          addr_range:
          [
            {
              base_addrs:
              {
                hart: 0x22030000
              }
              size_byte: 0x10
            }
          ]
          xbar: false
          stub: false
          pipeline: true
        }
        {
          name: soc_proxy.ctn
          type: device
          clock: clk_main_i
          reset: rst_main_ni
          pipefile: false
          inst_type: soc_proxy
          addr_range:
          [
            {
              base_addrs:
              {
                hart: 0x40000000
              }
              size_byte: 0x40000000
            }
          ]
          xbar: false
          stub: false
          pipeline: true
          req_fifo_pass: true
        }
        {
          name: rv_plic
          type: device
          clock: clk_main_i
          reset: rst_main_ni
          inst_type: rv_plic
          req_fifo_pass: false
          rsp_fifo_pass: false
          addr_range:
          [
            {
              base_addrs:
              {
                hart: 0x28000000
              }
              size_byte: 0x8000000
            }
          ]
          xbar: false
          stub: false
          pipeline: true
        }
        {
          name: rv_core_ibex.cfg
          type: device
          clock: clk_main_i
          reset: rst_main_ni
          req_fifo_pass: false
          rsp_fifo_pass: false
          inst_type: rv_core_ibex
          addr_range:
          [
            {
              base_addrs:
              {
                hart: 0x211f0000
              }
              size_byte: 0x100
            }
          ]
          xbar: false
          stub: false
          pipeline: true
        }
        {
          name: sram_ctrl_main.regs
          type: device
          clock: clk_main_i
          reset: rst_main_ni
          req_fifo_pass: false
          rsp_fifo_pass: false
          inst_type: sram_ctrl
          addr_range:
          [
            {
              base_addrs:
              {
                hart: 0x211c0000
              }
              size_byte: 0x40
            }
          ]
          xbar: false
          stub: false
          pipeline: true
        }
        {
          name: sram_ctrl_main.ram
          type: device
          clock: clk_main_i
          reset: rst_main_ni
          pipeline: false
          inst_type: sram_ctrl
          addr_range:
          [
            {
              base_addrs:
              {
                hart: 0x10000000
              }
              size_byte: 0x10000
            }
          ]
          xbar: false
          stub: false
          req_fifo_pass: true
        }
        {
          name: sram_ctrl_mbox.regs
          type: device
          clock: clk_main_i
          reset: rst_main_ni
          pipeline: false
          inst_type: sram_ctrl
          addr_range:
          [
            {
              base_addrs:
              {
                hart: 0x211d0000
              }
              size_byte: 0x40
            }
          ]
          xbar: false
          stub: false
          req_fifo_pass: true
        }
        {
          name: sram_ctrl_mbox.ram
          type: device
          clock: clk_main_i
          reset: rst_main_ni
          pipeline: false
          inst_type: sram_ctrl
          addr_range:
          [
            {
              base_addrs:
              {
                hart: 0x11000000
              }
              size_byte: 0x1000
            }
          ]
          xbar: false
          stub: false
          req_fifo_pass: true
        }
        {
          name: dma
          type: device
          clock: clk_main_i
          reset: rst_main_ni
          req_fifo_pass: false
          rsp_fifo_pass: false
          inst_type: dma
          addr_range:
          [
            {
              base_addrs:
              {
                hart: 0x22010000
              }
              size_byte: 0x200
            }
          ]
          xbar: false
          stub: false
          pipeline: true
        }
        {
          name: dma.host
          type: host
          addr_space: hart
          clock: clk_main_i
          reset: rst_main_ni
          pipeline: false
          xbar: false
          stub: false
          inst_type: ""
          req_fifo_pass: true
          rsp_fifo_pass: true
        }
        {
          name: mbx0.core
          type: device
          addr_space: hart
          clock: clk_main_i
          reset: rst_main_ni
          pipeline: false
          inst_type: mbx
          addr_range:
          [
            {
              base_addrs:
              {
                hart: 0x22000000
              }
              size_byte: 0x80
            }
          ]
          xbar: false
          stub: false
          req_fifo_pass: true
        }
        {
          name: mbx0.sram
          type: host
          addr_space: hart
          clock: clk_main_i
          reset: rst_main_ni
          pipeline: false
          xbar: false
          stub: false
          inst_type: ""
          req_fifo_pass: true
          rsp_fifo_pass: true
        }
        {
          name: mbx1.core
          type: device
          addr_space: hart
          clock: clk_main_i
          reset: rst_main_ni
          pipeline: false
          inst_type: mbx
          addr_range:
          [
            {
              base_addrs:
              {
                hart: 0x22000100
              }
              size_byte: 0x80
            }
          ]
          xbar: false
          stub: false
          req_fifo_pass: true
        }
        {
          name: mbx1.sram
          type: host
          addr_space: hart
          clock: clk_main_i
          reset: rst_main_ni
          pipeline: false
          xbar: false
          stub: false
          inst_type: ""
          req_fifo_pass: true
          rsp_fifo_pass: true
        }
        {
          name: mbx2.core
          type: device
          addr_space: hart
          clock: clk_main_i
          reset: rst_main_ni
          pipeline: false
          inst_type: mbx
          addr_range:
          [
            {
              base_addrs:
              {
                hart: 0x22000200
              }
              size_byte: 0x80
            }
          ]
          xbar: false
          stub: false
          req_fifo_pass: true
        }
        {
          name: mbx2.sram
          type: host
          addr_space: hart
          clock: clk_main_i
          reset: rst_main_ni
          pipeline: false
          xbar: false
          stub: false
          inst_type: ""
          req_fifo_pass: true
          rsp_fifo_pass: true
        }
        {
          name: mbx3.core
          type: device
          addr_space: hart
          clock: clk_main_i
          reset: rst_main_ni
          pipeline: false
          inst_type: mbx
          addr_range:
          [
            {
              base_addrs:
              {
                hart: 0x22000300
              }
              size_byte: 0x80
            }
          ]
          xbar: false
          stub: false
          req_fifo_pass: true
        }
        {
          name: mbx3.sram
          type: host
          addr_space: hart
          clock: clk_main_i
          reset: rst_main_ni
          pipeline: false
          xbar: false
          stub: false
          inst_type: ""
          req_fifo_pass: true
          rsp_fifo_pass: true
        }
        {
          name: mbx4.core
          type: device
          addr_space: hart
          clock: clk_main_i
          reset: rst_main_ni
          pipeline: false
          inst_type: mbx
          addr_range:
          [
            {
              base_addrs:
              {
                hart: 0x22000400
              }
              size_byte: 0x80
            }
          ]
          xbar: false
          stub: false
          req_fifo_pass: true
        }
        {
          name: mbx4.sram
          type: host
          addr_space: hart
          clock: clk_main_i
          reset: rst_main_ni
          pipeline: false
          xbar: false
          stub: false
          inst_type: ""
          req_fifo_pass: true
          rsp_fifo_pass: true
        }
        {
          name: mbx5.core
          type: device
          addr_space: hart
          clock: clk_main_i
          reset: rst_main_ni
          pipeline: false
          inst_type: mbx
          addr_range:
          [
            {
              base_addrs:
              {
                hart: 0x22000500
              }
              size_byte: 0x80
            }
          ]
          xbar: false
          stub: false
          req_fifo_pass: true
        }
        {
          name: mbx5.sram
          type: host
          addr_space: hart
          clock: clk_main_i
          reset: rst_main_ni
          pipeline: false
          xbar: false
          stub: false
          inst_type: ""
          req_fifo_pass: true
          rsp_fifo_pass: true
        }
      ]
      addr_spaces:
      [
        hart
      ]
      clock: clk_main_i
      type: xbar
      inter_signal_list:
      [
        {
          name: tl_rv_core_ibex__corei
          struct: tl
          package: tlul_pkg
          type: req_rsp
          act: rsp
          width: 1
          inst_name: pwc_main
          default: ""
          end_idx: -1
          top_signame: pwc_main_tl_rv_core_ibex__corei
          index: -1
        }
        {
          name: tl_rv_core_ibex__cored
          struct: tl
          package: tlul_pkg
          type: req_rsp
          act: rsp
          width: 1
          inst_name: pwc_main
          default: ""
          end_idx: -1
          top_signame: pwc_main_tl_rv_core_ibex__cored
          index: -1
        }
        {
          name: tl_rv_dm__sba
          struct: tl
          package: tlul_pkg
          type: req_rsp
          act: rsp
          width: 1
          inst_name: pwc_main
          default: ""
          end_idx: -1
          top_signame: pwc_main_tl_rv_dm__sba
          index: -1
        }
        {
          name: tl_dma__host
          struct: tl
          package: tlul_pkg
          type: req_rsp
          act: rsp
          width: 1
          inst_name: pwc_main
          default: ""
          end_idx: -1
          top_signame: pwc_main_tl_dma__host
          index: -1
        }
        {
          name: tl_mbx0__sram
          struct: tl
          package: tlul_pkg
          type: req_rsp
          act: rsp
          width: 1
          inst_name: pwc_main
          default: ""
          end_idx: -1
          top_signame: pwc_main_tl_mbx0__sram
          index: -1
        }
        {
          name: tl_mbx1__sram
          struct: tl
          package: tlul_pkg
          type: req_rsp
          act: rsp
          width: 1
          inst_name: pwc_main
          default: ""
          end_idx: -1
          top_signame: pwc_main_tl_mbx1__sram
          index: -1
        }
        {
          name: tl_mbx2__sram
          struct: tl
          package: tlul_pkg
          type: req_rsp
          act: rsp
          width: 1
          inst_name: pwc_main
          default: ""
          end_idx: -1
          top_signame: pwc_main_tl_mbx2__sram
          index: -1
        }
        {
          name: tl_mbx3__sram
          struct: tl
          package: tlul_pkg
          type: req_rsp
          act: rsp
          width: 1
          inst_name: pwc_main
          default: ""
          end_idx: -1
          top_signame: pwc_main_tl_mbx3__sram
          index: -1
        }
        {
          name: tl_mbx4__sram
          struct: tl
          package: tlul_pkg
          type: req_rsp
          act: rsp
          width: 1
          inst_name: pwc_main
          default: ""
          end_idx: -1
          top_signame: pwc_main_tl_mbx4__sram
          index: -1
        }
        {
          name: tl_mbx5__sram
          struct: tl
          package: tlul_pkg
          type: req_rsp
          act: rsp
          width: 1
          inst_name: pwc_main
          default: ""
          end_idx: -1
          top_signame: pwc_main_tl_mbx5__sram
          index: -1
        }
        {
          name: tl_rv_dm__regs
          struct: tl
          package: tlul_pkg
          type: req_rsp
          act: req
          width: 1
          inst_name: pwc_main
          default: ""
          top_signame: rv_dm_regs_tl_d
          index: -1
        }
        {
          name: tl_rv_dm__mem
          struct: tl
          package: tlul_pkg
          type: req_rsp
          act: req
          width: 1
          inst_name: pwc_main
          default: ""
          top_signame: rv_dm_mem_tl_d
          index: -1
        }
        {
          name: tl_pwc_peri
          struct: tl
          package: tlul_pkg
          type: req_rsp
          act: req
          width: 1
          inst_name: pwc_main
          default: ""
          end_idx: -1
          top_signame: pwc_main_tl_pwc_peri
          index: -1
        }
        {
          name: tl_soc_proxy__core
          struct: tl
          package: tlul_pkg
          type: req_rsp
          act: req
          width: 1
          inst_name: pwc_main
          default: ""
          top_signame: soc_proxy_core_tl
          index: -1
        }
        {
          name: tl_soc_proxy__ctn
          struct: tl
          package: tlul_pkg
          type: req_rsp
          act: req
          width: 1
          inst_name: pwc_main
          default: ""
          top_signame: soc_proxy_ctn_tl
          index: -1
        }
        {
          name: tl_rv_plic
          struct: tl
          package: tlul_pkg
          type: req_rsp
          act: req
          width: 1
          inst_name: pwc_main
          default: ""
          top_signame: rv_plic_tl
          index: -1
        }
        {
          name: tl_rv_core_ibex__cfg
          struct: tl
          package: tlul_pkg
          type: req_rsp
          act: req
          width: 1
          inst_name: pwc_main
          default: ""
          top_signame: rv_core_ibex_cfg_tl_d
          index: -1
        }
        {
          name: tl_sram_ctrl_main__regs
          struct: tl
          package: tlul_pkg
          type: req_rsp
          act: req
          width: 1
          inst_name: pwc_main
          default: ""
          top_signame: sram_ctrl_main_regs_tl
          index: -1
        }
        {
          name: tl_sram_ctrl_main__ram
          struct: tl
          package: tlul_pkg
          type: req_rsp
          act: req
          width: 1
          inst_name: pwc_main
          default: ""
          top_signame: sram_ctrl_main_ram_tl
          index: -1
        }
        {
          name: tl_sram_ctrl_mbox__regs
          struct: tl
          package: tlul_pkg
          type: req_rsp
          act: req
          width: 1
          inst_name: pwc_main
          default: ""
          top_signame: sram_ctrl_mbox_regs_tl
          index: -1
        }
        {
          name: tl_sram_ctrl_mbox__ram
          struct: tl
          package: tlul_pkg
          type: req_rsp
          act: req
          width: 1
          inst_name: pwc_main
          default: ""
          top_signame: sram_ctrl_mbox_ram_tl
          index: -1
        }
        {
          name: tl_dma
          struct: tl
          package: tlul_pkg
          type: req_rsp
          act: req
          width: 1
          inst_name: pwc_main
          default: ""
          top_signame: dma_tl_d
          index: -1
        }
        {
          name: tl_mbx0__core
          struct: tl
          package: tlul_pkg
          type: req_rsp
          act: req
          width: 1
          inst_name: pwc_main
          default: ""
          top_signame: mbx0_core_tl_d
          index: -1
        }
        {
          name: tl_mbx1__core
          struct: tl
          package: tlul_pkg
          type: req_rsp
          act: req
          width: 1
          inst_name: pwc_main
          default: ""
          top_signame: mbx1_core_tl_d
          index: -1
        }
        {
          name: tl_mbx2__core
          struct: tl
          package: tlul_pkg
          type: req_rsp
          act: req
          width: 1
          inst_name: pwc_main
          default: ""
          top_signame: mbx2_core_tl_d
          index: -1
        }
        {
          name: tl_mbx3__core
          struct: tl
          package: tlul_pkg
          type: req_rsp
          act: req
          width: 1
          inst_name: pwc_main
          default: ""
          top_signame: mbx3_core_tl_d
          index: -1
        }
        {
          name: tl_mbx4__core
          struct: tl
          package: tlul_pkg
          type: req_rsp
          act: req
          width: 1
          inst_name: pwc_main
          default: ""
          top_signame: mbx4_core_tl_d
          index: -1
        }
        {
          name: tl_mbx5__core
          struct: tl
          package: tlul_pkg
          type: req_rsp
          act: req
          width: 1
          inst_name: pwc_main
          default: ""
          top_signame: mbx5_core_tl_d
          index: -1
        }
      ]
    }
    {
      name: pwc_peri
      clock_srcs:
      {
        clk_peri_i: ext_io_div4
      }
      clock_group: infra
      reset: rst_peri_ni
      reset_connections:
      {
        rst_peri_ni:
        {
          name: ext_rst_io_div4
          domain: "0"
        }
      }
      clock_connections:
      {
        clk_peri_i: clk_ext_io_div4_i
      }
      domain:
      [
        "0"
      ]
      connections:
      {
        pwc_main:
        [
          gpio
          rv_timer
          sram_ctrl_ret_aon.ram
          sram_ctrl_ret_aon.regs
          aon_timer_aon
        ]
      }
      nodes:
      [
        {
          name: pwc_main
          type: host
          addr_space: hart
          clock: clk_peri_i
          reset: rst_peri_ni
          xbar: true
          pipeline: false
          stub: false
          inst_type: ""
          req_fifo_pass: true
          rsp_fifo_pass: true
        }
        {
          name: gpio
          type: device
          clock: clk_peri_i
          reset: rst_peri_ni
          pipeline: false
          inst_type: gpio
          addr_range:
          [
            {
              base_addrs:
              {
                hart: 0x30000000
              }
              size_byte: 0x80
            }
          ]
          xbar: false
          stub: false
          req_fifo_pass: true
        }
        {
          name: rv_timer
          type: device
          clock: clk_peri_i
          reset: rst_peri_ni
          pipeline: false
          inst_type: rv_timer
          addr_range:
          [
            {
              base_addrs:
              {
                hart: 0x30100000
              }
              size_byte: 0x200
            }
          ]
          xbar: false
          stub: false
          req_fifo_pass: true
        }
        {
          name: sram_ctrl_ret_aon.regs
          type: device
          clock: clk_peri_i
          reset: rst_peri_ni
          pipeline: false
          inst_type: sram_ctrl
          addr_range:
          [
            {
              base_addrs:
              {
                hart: 0x30500000
              }
              size_byte: 0x40
            }
          ]
          xbar: false
          stub: false
          req_fifo_pass: true
        }
        {
          name: sram_ctrl_ret_aon.ram
          type: device
          clock: clk_peri_i
          reset: rst_peri_ni
          pipeline: false
          inst_type: sram_ctrl
          addr_range:
          [
            {
              base_addrs:
              {
                hart: 0x30600000
              }
              size_byte: 0x1000
            }
          ]
          xbar: false
          stub: false
          req_fifo_pass: true
        }
        {
          name: aon_timer_aon
          type: device
          clock: clk_peri_i
          reset: rst_peri_ni
          pipeline: false
          inst_type: aon_timer
          addr_range:
          [
            {
              base_addrs:
              {
                hart: 0x30470000
              }
              size_byte: 0x40
            }
          ]
          xbar: false
          stub: false
          req_fifo_pass: true
        }
      ]
      addr_spaces:
      [
        hart
      ]
      clock: clk_peri_i
      type: xbar
      inter_signal_list:
      [
        {
          name: tl_pwc_main
          struct: tl
          package: tlul_pkg
          type: req_rsp
          act: rsp
          width: 1
          inst_name: pwc_peri
          default: ""
          top_signame: pwc_main_tl_pwc_peri
          index: -1
        }
        {
          name: tl_gpio
          struct: tl
          package: tlul_pkg
          type: req_rsp
          act: req
          width: 1
          inst_name: pwc_peri
          default: ""
          top_signame: gpio_tl
          index: -1
        }
        {
          name: tl_rv_timer
          struct: tl
          package: tlul_pkg
          type: req_rsp
          act: req
          width: 1
          inst_name: pwc_peri
          default: ""
          top_signame: rv_timer_tl
          index: -1
        }
        {
          name: tl_sram_ctrl_ret_aon__regs
          struct: tl
          package: tlul_pkg
          type: req_rsp
          act: req
          width: 1
          inst_name: pwc_peri
          default: ""
          top_signame: sram_ctrl_ret_aon_regs_tl
          index: -1
        }
        {
          name: tl_sram_ctrl_ret_aon__ram
          struct: tl
          package: tlul_pkg
          type: req_rsp
          act: req
          width: 1
          inst_name: pwc_peri
          default: ""
          top_signame: sram_ctrl_ret_aon_ram_tl
          index: -1
        }
        {
          name: tl_aon_timer_aon
          struct: tl
          package: tlul_pkg
          type: req_rsp
          act: req
          width: 1
          inst_name: pwc_peri
          default: ""
          top_signame: aon_timer_aon_tl
          index: -1
        }
      ]
    }
    {
      name: pwc_mbx
      clock_srcs:
      {
        clk_mbx_i: ext_main
      }
      clock_group: infra
      reset: rst_mbx_ni
      reset_connections:
      {
        rst_mbx_ni:
        {
          name: ext_rst_main
          domain: "0"
        }
      }
      clock_connections:
      {
        clk_mbx_i: clk_ext_main_i
      }
      domain:
      [
        "0"
      ]
      connections:
      {
        pwc_mbx:
        [
          mbx0.soc
          mbx1.soc
          mbx2.soc
          mbx3.soc
          mbx4.soc
          mbx5.soc
        ]
      }
      nodes:
      [
        {
          name: pwc_mbx
          type: host
          addr_space: soc_mbx
          clock: clk_mbx_i
          reset: rst_mbx_ni
          xbar: true
          pipeline: false
          stub: false
          inst_type: ""
          req_fifo_pass: true
          rsp_fifo_pass: true
        }
        {
          name: mbx0.soc
          type: device
          addr_space: soc_mbx
          clock: clk_mbx_i
          reset: rst_mbx_ni
          pipeline: false
          inst_type: mbx
          addr_range:
          [
            {
              base_addrs:
              {
                soc_mbx: 0x1465000
              }
              size_byte: 0x20
            }
          ]
          xbar: false
          stub: false
          req_fifo_pass: true
        }
        {
          name: mbx1.soc
          type: device
          addr_space: soc_mbx
          clock: clk_mbx_i
          reset: rst_mbx_ni
          pipeline: false
          inst_type: mbx
          addr_range:
          [
            {
              base_addrs:
              {
                soc_mbx: 0x1465100
              }
              size_byte: 0x20
            }
          ]
          xbar: false
          stub: false
          req_fifo_pass: true
        }
        {
          name: mbx2.soc
          type: device
          addr_space: soc_mbx
          clock: clk_mbx_i
          reset: rst_mbx_ni
          pipeline: false
          inst_type: mbx
          addr_range:
          [
            {
              base_addrs:
              {
                soc_mbx: 0x1465200
              }
              size_byte: 0x20
            }
          ]
          xbar: false
          stub: false
          req_fifo_pass: true
        }
        {
          name: mbx3.soc
          type: device
          addr_space: soc_mbx
          clock: clk_mbx_i
          reset: rst_mbx_ni
          pipeline: false
          inst_type: mbx
          addr_range:
          [
            {
              base_addrs:
              {
                soc_mbx: 0x1465300
              }
              size_byte: 0x20
            }
          ]
          xbar: false
          stub: false
          req_fifo_pass: true
        }
        {
          name: mbx4.soc
          type: device
          addr_space: soc_mbx
          clock: clk_mbx_i
          reset: rst_mbx_ni
          pipeline: false
          inst_type: mbx
          addr_range:
          [
            {
              base_addrs:
              {
                soc_mbx: 0x1465400
              }
              size_byte: 0x20
            }
          ]
          xbar: false
          stub: false
          req_fifo_pass: true
        }
        {
          name: mbx5.soc
          type: device
          addr_space: soc_mbx
          clock: clk_mbx_i
          reset: rst_mbx_ni
          pipeline: false
          inst_type: mbx
          addr_range:
          [
            {
              base_addrs:
              {
                soc_mbx: 0x1465500
              }
              size_byte: 0x20
            }
          ]
          xbar: false
          stub: false
          req_fifo_pass: true
        }
      ]
      addr_spaces:
      [
        soc_mbx
      ]
      clock: clk_mbx_i
      type: xbar
      inter_signal_list:
      [
        {
          name: tl_pwc_mbx
          struct: tl
          package: tlul_pkg
          type: req_rsp
          act: rsp
          width: 1
          inst_name: pwc_mbx
          default: ""
          external: true
          top_signame: mbx_tl
          conn_type: false
          index: -1
        }
        {
          name: tl_mbx0__soc
          struct: tl
          package: tlul_pkg
          type: req_rsp
          act: req
          width: 1
          inst_name: pwc_mbx
          default: ""
          top_signame: mbx0_soc_tl_d
          index: -1
        }
        {
          name: tl_mbx1__soc
          struct: tl
          package: tlul_pkg
          type: req_rsp
          act: req
          width: 1
          inst_name: pwc_mbx
          default: ""
          top_signame: mbx1_soc_tl_d
          index: -1
        }
        {
          name: tl_mbx2__soc
          struct: tl
          package: tlul_pkg
          type: req_rsp
          act: req
          width: 1
          inst_name: pwc_mbx
          default: ""
          top_signame: mbx2_soc_tl_d
          index: -1
        }
        {
          name: tl_mbx3__soc
          struct: tl
          package: tlul_pkg
          type: req_rsp
          act: req
          width: 1
          inst_name: pwc_mbx
          default: ""
          top_signame: mbx3_soc_tl_d
          index: -1
        }
        {
          name: tl_mbx4__soc
          struct: tl
          package: tlul_pkg
          type: req_rsp
          act: req
          width: 1
          inst_name: pwc_mbx
          default: ""
          top_signame: mbx4_soc_tl_d
          index: -1
        }
        {
          name: tl_mbx5__soc
          struct: tl
          package: tlul_pkg
          type: req_rsp
          act: req
          width: 1
          inst_name: pwc_mbx
          default: ""
          top_signame: mbx5_soc_tl_d
          index: -1
        }
      ]
    }
  ]
  pinout:
  {
    banks:
    [
      VIO
    ]
    pads: []
  }
  pinmux:
  {
    signals: []
    num_wkup_detect: 8
    wkup_cnt_width: 8
    enable_usb_wakeup: false
    enable_strap_sampling: false
  }
  targets: []
  incoming_alert: {}
  incoming_interrupt:
  {
    pwc_external:
    [
      {
        name: PWC_LTEU_SOC_HOT
        module_name: PWC_LTEU
        type: interrupt
        intr_type: IntrType.Event
        default_val: false
        incoming: true
        width: 1
      }
      {
        name: PWC_LTEU_FW_TRIP
        module_name: PWC_LTEU
        type: interrupt
        intr_type: IntrType.Event
        default_val: false
        incoming: true
        width: 1
      }
      {
        name: PWC_LTEU_CAT_TRIP
        module_name: PWC_LTEU
        type: interrupt
        intr_type: IntrType.Event
        default_val: false
        incoming: true
        width: 1
      }
      {
        name: LIO_GRP_A_IBEX_IRQ
        module_name: LIO_GRP_A
        type: interrupt
        intr_type: IntrType.Event
        default_val: false
        incoming: true
        width: 1
      }
      {
        name: LIO_GRP_B_IBEX_IRQ
        module_name: LIO_GRP_B
        type: interrupt
        intr_type: IntrType.Event
        default_val: false
        incoming: true
        width: 1
      }
      {
        name: LIO_GRP_C_IBEX_IRQ
        module_name: LIO_GRP_C
        type: interrupt
        intr_type: IntrType.Event
        default_val: false
        incoming: true
        width: 1
      }
      {
        name: PWC_DVFS_SocDpaFsmstatus0
        module_name: PWC_DVFS
        type: interrupt
        intr_type: IntrType.Event
        default_val: false
        incoming: true
        width: 1
      }
      {
        name: PWC_DVFS_SocDpaFsmstatus1
        module_name: PWC_DVFS
        type: interrupt
        intr_type: IntrType.Event
        default_val: false
        incoming: true
        width: 1
      }
      {
        name: PWC_DVFS_SocDpaFsmstatus2
        module_name: PWC_DVFS
        type: interrupt
        intr_type: IntrType.Event
        default_val: false
        incoming: true
        width: 1
      }
      {
        name: PWC_DVFS_SocDpaFsmstatus3
        module_name: PWC_DVFS
        type: interrupt
        intr_type: IntrType.Event
        default_val: false
        incoming: true
        width: 1
      }
      {
        name: PWC_DVFS_SocDpaFsmstatus4
        module_name: PWC_DVFS
        type: interrupt
        intr_type: IntrType.Event
        default_val: false
        incoming: true
        width: 1
      }
      {
        name: PWC_DVFS_TargetCmdAVS0
        module_name: PWC_DVFS
        type: interrupt
        intr_type: IntrType.Event
        default_val: false
        incoming: true
        width: 1
      }
      {
        name: PWC_DVFS_TargetCmdAVS1
        module_name: PWC_DVFS
        type: interrupt
        intr_type: IntrType.Event
        default_val: false
        incoming: true
        width: 1
      }
      {
        name: PWC_DVFS_TargetCmdAVS2
        module_name: PWC_DVFS
        type: interrupt
        intr_type: IntrType.Event
        default_val: false
        incoming: true
        width: 1
      }
      {
        name: PWC_DVFS_TargetCmdAVS3
        module_name: PWC_DVFS
        type: interrupt
        intr_type: IntrType.Event
        default_val: false
        incoming: true
        width: 1
      }
      {
        name: PWC_DVFS_TargetCmdAVS4
        module_name: PWC_DVFS
        type: interrupt
        intr_type: IntrType.Event
        default_val: false
        incoming: true
        width: 1
      }
      {
        name: PWC_DVFS_TargetCmdAVS5
        module_name: PWC_DVFS
        type: interrupt
        intr_type: IntrType.Event
        default_val: false
        incoming: true
        width: 1
      }
      {
        name: PWC_DVFS_TargetCmdAVS6
        module_name: PWC_DVFS
        type: interrupt
        intr_type: IntrType.Event
        default_val: false
        incoming: true
        width: 1
      }
      {
        name: PWC_DVFS_TargetCmdAVS7
        module_name: PWC_DVFS
        type: interrupt
        intr_type: IntrType.Event
        default_val: false
        incoming: true
        width: 1
      }
      {
        name: PWC_DVFS_TargetCmdAVS8
        module_name: PWC_DVFS
        type: interrupt
        intr_type: IntrType.Event
        default_val: false
        incoming: true
        width: 1
      }
      {
        name: PWC_DVFS_TargetCmdAVS9
        module_name: PWC_DVFS
        type: interrupt
        intr_type: IntrType.Event
        default_val: false
        incoming: true
        width: 1
      }
      {
        name: PWC_DVFS_TargetCmdAVS10
        module_name: PWC_DVFS
        type: interrupt
        intr_type: IntrType.Event
        default_val: false
        incoming: true
        width: 1
      }
      {
        name: PWC_DVFS_TargetCmdAVS11
        module_name: PWC_DVFS
        type: interrupt
        intr_type: IntrType.Event
        default_val: false
        incoming: true
        width: 1
      }
      {
        name: PWC_DVFS_TargetCmdAVS12
        module_name: PWC_DVFS
        type: interrupt
        intr_type: IntrType.Event
        default_val: false
        incoming: true
        width: 1
      }
      {
        name: PWC_DVFS_TargetCmdAVS13
        module_name: PWC_DVFS
        type: interrupt
        intr_type: IntrType.Event
        default_val: false
        incoming: true
        width: 1
      }
      {
        name: PWC_AVS_AVS_ERROR_0
        module_name: PWC_AVS
        type: interrupt
        intr_type: IntrType.Event
        default_val: false
        incoming: true
        width: 1
      }
      {
        name: PWC_AVS_AVS_ERROR_1
        module_name: PWC_AVS
        type: interrupt
        intr_type: IntrType.Event
        default_val: false
        incoming: true
        width: 1
      }
      {
        name: PWC_AVS_AVS_ERROR_2
        module_name: PWC_AVS
        type: interrupt
        intr_type: IntrType.Event
        default_val: false
        incoming: true
        width: 1
      }
      {
        name: PWC_AVS_AVS_ERROR_3
        module_name: PWC_AVS
        type: interrupt
        intr_type: IntrType.Event
        default_val: false
        incoming: true
        width: 1
      }
      {
        name: PWC_AVS_AVS_ERROR_4
        module_name: PWC_AVS
        type: interrupt
        intr_type: IntrType.Event
        default_val: false
        incoming: true
        width: 1
      }
      {
        name: PWC_AVS_AVS_ERROR_5
        module_name: PWC_AVS
        type: interrupt
        intr_type: IntrType.Event
        default_val: false
        incoming: true
        width: 1
      }
      {
        name: PWC_AVS_AVS_ERROR_6
        module_name: PWC_AVS
        type: interrupt
        intr_type: IntrType.Event
        default_val: false
        incoming: true
        width: 1
      }
      {
        name: PWC_AVS_AVS_ERROR_7
        module_name: PWC_AVS
        type: interrupt
        intr_type: IntrType.Event
        default_val: false
        incoming: true
        width: 1
      }
      {
        name: PWC_AVS_AVS_ERROR_8
        module_name: PWC_AVS
        type: interrupt
        intr_type: IntrType.Event
        default_val: false
        incoming: true
        width: 1
      }
      {
        name: PWC_AVS_AVS_ERROR_9
        module_name: PWC_AVS
        type: interrupt
        intr_type: IntrType.Event
        default_val: false
        incoming: true
        width: 1
      }
      {
        name: PWC_AVS_AVS_ERROR_10
        module_name: PWC_AVS
        type: interrupt
        intr_type: IntrType.Event
        default_val: false
        incoming: true
        width: 1
      }
      {
        name: PWC_AVS_AVS_ERROR_11
        module_name: PWC_AVS
        type: interrupt
        intr_type: IntrType.Event
        default_val: false
        incoming: true
        width: 1
      }
      {
        name: PWC_AVS_AVS_ERROR_12
        module_name: PWC_AVS
        type: interrupt
        intr_type: IntrType.Event
        default_val: false
        incoming: true
        width: 1
      }
      {
        name: PWC_AVS_AVS_ERROR_13
        module_name: PWC_AVS
        type: interrupt
        intr_type: IntrType.Event
        default_val: false
        incoming: true
        width: 1
      }
      {
        name: PWC_AVS_AVS_ERROR_14
        module_name: PWC_AVS
        type: interrupt
        intr_type: IntrType.Event
        default_val: false
        incoming: true
        width: 1
      }
      {
        name: PWC_AVS_AVS_ERROR_15
        module_name: PWC_AVS
        type: interrupt
        intr_type: IntrType.Event
        default_val: false
        incoming: true
        width: 1
      }
      {
        name: PWC_AVS_AVS_ERROR_16
        module_name: PWC_AVS
        type: interrupt
        intr_type: IntrType.Event
        default_val: false
        incoming: true
        width: 1
      }
      {
        name: PWC_AVS_AVS_ERROR_17
        module_name: PWC_AVS
        type: interrupt
        intr_type: IntrType.Event
        default_val: false
        incoming: true
        width: 1
      }
      {
        name: PWC_AVS_AVS_ERROR_18
        module_name: PWC_AVS
        type: interrupt
        intr_type: IntrType.Event
        default_val: false
        incoming: true
        width: 1
      }
      {
        name: PWC_AVS_AVS_ERROR_19
        module_name: PWC_AVS
        type: interrupt
        intr_type: IntrType.Event
        default_val: false
        incoming: true
        width: 1
      }
      {
        name: PWC_AVS_AVS_ERROR_20
        module_name: PWC_AVS
        type: interrupt
        intr_type: IntrType.Event
        default_val: false
        incoming: true
        width: 1
      }
      {
        name: PWC_AVS_AVS_RESPONSE_TO_FW_0
        module_name: PWC_AVS
        type: interrupt
        intr_type: IntrType.Event
        default_val: false
        incoming: true
        width: 1
      }
      {
        name: PWC_AVS_AVS_RESPONSE_TO_FW_1
        module_name: PWC_AVS
        type: interrupt
        intr_type: IntrType.Event
        default_val: false
        incoming: true
        width: 1
      }
      {
        name: PWC_AVS_AVS_RESPONSE_TO_FW_2
        module_name: PWC_AVS
        type: interrupt
        intr_type: IntrType.Event
        default_val: false
        incoming: true
        width: 1
      }
      {
        name: PWC_AVS_AVS_RESPONSE_TO_FW_3
        module_name: PWC_AVS
        type: interrupt
        intr_type: IntrType.Event
        default_val: false
        incoming: true
        width: 1
      }
      {
        name: PWC_AVS_AVS_RESPONSE_TO_FW_4
        module_name: PWC_AVS
        type: interrupt
        intr_type: IntrType.Event
        default_val: false
        incoming: true
        width: 1
      }
      {
        name: PWC_AVS_AVS_RESPONSE_TO_FW_5
        module_name: PWC_AVS
        type: interrupt
        intr_type: IntrType.Event
        default_val: false
        incoming: true
        width: 1
      }
      {
        name: PWC_AVS_AVS_RESPONSE_TO_FW_6
        module_name: PWC_AVS
        type: interrupt
        intr_type: IntrType.Event
        default_val: false
        incoming: true
        width: 1
      }
      {
        name: PWC_AVS_AVS_RESPONSE_TO_FW_7
        module_name: PWC_AVS
        type: interrupt
        intr_type: IntrType.Event
        default_val: false
        incoming: true
        width: 1
      }
      {
        name: PWC_AVS_AVS_RESPONSE_TO_FW_8
        module_name: PWC_AVS
        type: interrupt
        intr_type: IntrType.Event
        default_val: false
        incoming: true
        width: 1
      }
      {
        name: PWC_AVS_AVS_RESPONSE_TO_FW_9
        module_name: PWC_AVS
        type: interrupt
        intr_type: IntrType.Event
        default_val: false
        incoming: true
        width: 1
      }
      {
        name: PWC_AVS_AVS_RESPONSE_TO_FW_10
        module_name: PWC_AVS
        type: interrupt
        intr_type: IntrType.Event
        default_val: false
        incoming: true
        width: 1
      }
      {
        name: PWC_AVS_AVS_RESPONSE_TO_FW_11
        module_name: PWC_AVS
        type: interrupt
        intr_type: IntrType.Event
        default_val: false
        incoming: true
        width: 1
      }
      {
        name: PWC_AVS_AVS_RESPONSE_TO_FW_12
        module_name: PWC_AVS
        type: interrupt
        intr_type: IntrType.Event
        default_val: false
        incoming: true
        width: 1
      }
      {
        name: PWC_AVS_AVS_RESPONSE_TO_FW_13
        module_name: PWC_AVS
        type: interrupt
        intr_type: IntrType.Event
        default_val: false
        incoming: true
        width: 1
      }
      {
        name: PWC_AVS_AVS_RESPONSE_TO_FW_14
        module_name: PWC_AVS
        type: interrupt
        intr_type: IntrType.Event
        default_val: false
        incoming: true
        width: 1
      }
      {
        name: PWC_AVS_AVS_RESPONSE_TO_FW_15
        module_name: PWC_AVS
        type: interrupt
        intr_type: IntrType.Event
        default_val: false
        incoming: true
        width: 1
      }
      {
        name: PWC_AVS_AVS_RESPONSE_TO_FW_16
        module_name: PWC_AVS
        type: interrupt
        intr_type: IntrType.Event
        default_val: false
        incoming: true
        width: 1
      }
      {
        name: PWC_AVS_AVS_RESPONSE_TO_FW_17
        module_name: PWC_AVS
        type: interrupt
        intr_type: IntrType.Event
        default_val: false
        incoming: true
        width: 1
      }
      {
        name: PWC_AVS_AVS_RESPONSE_TO_FW_18
        module_name: PWC_AVS
        type: interrupt
        intr_type: IntrType.Event
        default_val: false
        incoming: true
        width: 1
      }
      {
        name: PWC_AVS_AVS_RESPONSE_TO_FW_19
        module_name: PWC_AVS
        type: interrupt
        intr_type: IntrType.Event
        default_val: false
        incoming: true
        width: 1
      }
      {
        name: PWC_AVS_AVS_RESPONSE_TO_FW_20
        module_name: PWC_AVS
        type: interrupt
        intr_type: IntrType.Event
        default_val: false
        incoming: true
        width: 1
      }
      {
        name: PWC_AVS_AVS_RESPONSE_TO_FW_21
        module_name: PWC_AVS
        type: interrupt
        intr_type: IntrType.Event
        default_val: false
        incoming: true
        width: 1
      }
      {
        name: PWC_AVS_AVS_RESPONSE_TO_FW_22
        module_name: PWC_AVS
        type: interrupt
        intr_type: IntrType.Event
        default_val: false
        incoming: true
        width: 1
      }
      {
        name: PWC_AVS_AVS_RESPONSE_TO_FW_23
        module_name: PWC_AVS
        type: interrupt
        intr_type: IntrType.Event
        default_val: false
        incoming: true
        width: 1
      }
      {
        name: PWC_AVS_AVS_RESPONSE_TO_FW_24
        module_name: PWC_AVS
        type: interrupt
        intr_type: IntrType.Event
        default_val: false
        incoming: true
        width: 1
      }
      {
        name: PWC_AVS_AVS_RESPONSE_TO_FW_25
        module_name: PWC_AVS
        type: interrupt
        intr_type: IntrType.Event
        default_val: false
        incoming: true
        width: 1
      }
      {
        name: PWC_AVS_AVS_RESPONSE_TO_FW_26
        module_name: PWC_AVS
        type: interrupt
        intr_type: IntrType.Event
        default_val: false
        incoming: true
        width: 1
      }
      {
        name: PWC_AVS_AVS_RESPONSE_TO_FW_27
        module_name: PWC_AVS
        type: interrupt
        intr_type: IntrType.Event
        default_val: false
        incoming: true
        width: 1
      }
      {
        name: PWC_AVS_AVS_RESPONSE_TO_FW_28
        module_name: PWC_AVS
        type: interrupt
        intr_type: IntrType.Event
        default_val: false
        incoming: true
        width: 1
      }
      {
        name: PWC_BCAST_C_STATE_ENTRY
        module_name: PWC_BCAST
        type: interrupt
        intr_type: IntrType.Event
        default_val: false
        incoming: true
        width: 1
      }
      {
        name: PWC_BCAST_C_STATE_EXIT
        module_name: PWC_BCAST
        type: interrupt
        intr_type: IntrType.Event
        default_val: false
        incoming: true
        width: 1
      }
      {
        name: PWC_BCAST_DPA_IDLE_ENTRY
        module_name: PWC_BCAST
        type: interrupt
        intr_type: IntrType.Event
        default_val: false
        incoming: true
        width: 1
      }
      {
        name: PWC_BCAST_DPA_IDLE_EXIT
        module_name: PWC_BCAST
        type: interrupt
        intr_type: IntrType.Event
        default_val: false
        incoming: true
        width: 1
      }
      {
        name: PWC_CCS_0_PWR_VIRUS_LVL_REQ
        module_name: PWC_CCS_0
        type: interrupt
        intr_type: IntrType.Event
        default_val: false
        incoming: true
        width: 1
      }
      {
        name: PWC_CCS_1_PWR_VIRUS_LVL_REQ
        module_name: PWC_CCS_1
        type: interrupt
        intr_type: IntrType.Event
        default_val: false
        incoming: true
        width: 1
      }
      {
        name: PWC_CCS_2_PWR_VIRUS_LVL_REQ
        module_name: PWC_CCS_2
        type: interrupt
        intr_type: IntrType.Event
        default_val: false
        incoming: true
        width: 1
      }
      {
        name: PWC_CCS_3_PWR_VIRUS_LVL_REQ
        module_name: PWC_CCS_3
        type: interrupt
        intr_type: IntrType.Event
        default_val: false
        incoming: true
        width: 1
      }
      {
        name: PWC_CCS_4_PWR_VIRUS_LVL_REQ
        module_name: PWC_CCS_4
        type: interrupt
        intr_type: IntrType.Event
        default_val: false
        incoming: true
        width: 1
      }
      {
        name: PWC_CCS_5_PWR_VIRUS_LVL_REQ
        module_name: PWC_CCS_5
        type: interrupt
        intr_type: IntrType.Event
        default_val: false
        incoming: true
        width: 1
      }
      {
        name: PWC_CCS_6_PWR_VIRUS_LVL_REQ
        module_name: PWC_CCS_6
        type: interrupt
        intr_type: IntrType.Event
        default_val: false
        incoming: true
        width: 1
      }
      {
        name: PWC_CCS_7_PWR_VIRUS_LVL_REQ
        module_name: PWC_CCS_7
        type: interrupt
        intr_type: IntrType.Event
        default_val: false
        incoming: true
        width: 1
      }
      {
        name: PWC_CCS_0_DVFS_FSM
        module_name: PWC_CCS_0
        type: interrupt
        intr_type: IntrType.Event
        default_val: false
        incoming: true
        width: 1
      }
      {
        name: PWC_CCS_1_DVFS_FSM
        module_name: PWC_CCS_1
        type: interrupt
        intr_type: IntrType.Event
        default_val: false
        incoming: true
        width: 1
      }
      {
        name: PWC_CCS_2_DVFS_FSM
        module_name: PWC_CCS_2
        type: interrupt
        intr_type: IntrType.Event
        default_val: false
        incoming: true
        width: 1
      }
      {
        name: PWC_CCS_3_DVFS_FSM
        module_name: PWC_CCS_3
        type: interrupt
        intr_type: IntrType.Event
        default_val: false
        incoming: true
        width: 1
      }
      {
        name: PWC_CCS_4_DVFS_FSM
        module_name: PWC_CCS_4
        type: interrupt
        intr_type: IntrType.Event
        default_val: false
        incoming: true
        width: 1
      }
      {
        name: PWC_CCS_5_DVFS_FSM
        module_name: PWC_CCS_5
        type: interrupt
        intr_type: IntrType.Event
        default_val: false
        incoming: true
        width: 1
      }
      {
        name: PWC_CCS_6_DVFS_FSM
        module_name: PWC_CCS_6
        type: interrupt
        intr_type: IntrType.Event
        default_val: false
        incoming: true
        width: 1
      }
      {
        name: PWC_CCS_7_DVFS_FSM
        module_name: PWC_CCS_7
        type: interrupt
        intr_type: IntrType.Event
        default_val: false
        incoming: true
        width: 1
      }
      {
        name: PWC_HMS_East_STATUS
        module_name: PWC_HMS
        type: interrupt
        intr_type: IntrType.Event
        default_val: false
        incoming: true
        width: 1
      }
      {
        name: PWC_HMS_WEST_STATUS
        module_name: PWC_HMS
        type: interrupt
        intr_type: IntrType.Event
        default_val: false
        incoming: true
        width: 1
      }
      {
        name: PWC_PCS_0_ALL_PORTS_STATUS
        module_name: PWC_PCS_0
        type: interrupt
        intr_type: IntrType.Event
        default_val: false
        incoming: true
        width: 1
      }
      {
        name: PWC_PCS_0_LINK_BRINGUP_0
        module_name: PWC_PCS_0
        type: interrupt
        intr_type: IntrType.Event
        default_val: false
        incoming: true
        width: 1
      }
      {
        name: PWC_PCS_0_LINK_BRINGUP_1
        module_name: PWC_PCS_0
        type: interrupt
        intr_type: IntrType.Event
        default_val: false
        incoming: true
        width: 1
      }
      {
        name: PWC_PCS_0_LINK_BRINGUP_2
        module_name: PWC_PCS_0
        type: interrupt
        intr_type: IntrType.Event
        default_val: false
        incoming: true
        width: 1
      }
      {
        name: PWC_PCS_0_LINK_BRINGUP_3
        module_name: PWC_PCS_0
        type: interrupt
        intr_type: IntrType.Event
        default_val: false
        incoming: true
        width: 1
      }
      {
        name: PWC_PCS_0_MSG_CTRL
        module_name: PWC_PCS_0
        type: interrupt
        intr_type: IntrType.Event
        default_val: false
        incoming: true
        width: 1
      }
      {
        name: PWC_PCS_0_PHY_STATUS
        module_name: PWC_PCS_0
        type: interrupt
        intr_type: IntrType.Event
        default_val: false
        incoming: true
        width: 1
      }
      {
        name: PWC_PCS_1_ALL_PORTS_STATUS
        module_name: PWC_PCS_1
        type: interrupt
        intr_type: IntrType.Event
        default_val: false
        incoming: true
        width: 1
      }
      {
        name: PWC_PCS_1_LINK_BRINGUP_0
        module_name: PWC_PCS_1
        type: interrupt
        intr_type: IntrType.Event
        default_val: false
        incoming: true
        width: 1
      }
      {
        name: PWC_PCS_1_LINK_BRINGUP_1
        module_name: PWC_PCS_1
        type: interrupt
        intr_type: IntrType.Event
        default_val: false
        incoming: true
        width: 1
      }
      {
        name: PWC_PCS_1_LINK_BRINGUP_2
        module_name: PWC_PCS_1
        type: interrupt
        intr_type: IntrType.Event
        default_val: false
        incoming: true
        width: 1
      }
      {
        name: PWC_PCS_1_LINK_BRINGUP_3
        module_name: PWC_PCS_1
        type: interrupt
        intr_type: IntrType.Event
        default_val: false
        incoming: true
        width: 1
      }
      {
        name: PWC_PCS_1_MSG_CTRL
        module_name: PWC_PCS_1
        type: interrupt
        intr_type: IntrType.Event
        default_val: false
        incoming: true
        width: 1
      }
      {
        name: PWC_PCS_1_PHY_STATUS
        module_name: PWC_PCS_1
        type: interrupt
        intr_type: IntrType.Event
        default_val: false
        incoming: true
        width: 1
      }
      {
        name: PWC_PCS_2_ALL_PORTS_STATUS
        module_name: PWC_PCS_2
        type: interrupt
        intr_type: IntrType.Event
        default_val: false
        incoming: true
        width: 1
      }
      {
        name: PWC_PCS_2_LINK_BRINGUP_0
        module_name: PWC_PCS_2
        type: interrupt
        intr_type: IntrType.Event
        default_val: false
        incoming: true
        width: 1
      }
      {
        name: PWC_PCS_2_LINK_BRINGUP_1
        module_name: PWC_PCS_2
        type: interrupt
        intr_type: IntrType.Event
        default_val: false
        incoming: true
        width: 1
      }
      {
        name: PWC_PCS_2_LINK_BRINGUP_2
        module_name: PWC_PCS_2
        type: interrupt
        intr_type: IntrType.Event
        default_val: false
        incoming: true
        width: 1
      }
      {
        name: PWC_PCS_2_LINK_BRINGUP_3
        module_name: PWC_PCS_2
        type: interrupt
        intr_type: IntrType.Event
        default_val: false
        incoming: true
        width: 1
      }
      {
        name: PWC_PCS_2_MSG_CTRL
        module_name: PWC_PCS_2
        type: interrupt
        intr_type: IntrType.Event
        default_val: false
        incoming: true
        width: 1
      }
      {
        name: PWC_PCS_2_PHY_STATUS
        module_name: PWC_PCS_2
        type: interrupt
        intr_type: IntrType.Event
        default_val: false
        incoming: true
        width: 1
      }
      {
        name: PWC_PCS_3_ALL_PORTS_STATUS
        module_name: PWC_PCS_3
        type: interrupt
        intr_type: IntrType.Event
        default_val: false
        incoming: true
        width: 1
      }
      {
        name: PWC_PCS_3_LINK_BRINGUP_0
        module_name: PWC_PCS_3
        type: interrupt
        intr_type: IntrType.Event
        default_val: false
        incoming: true
        width: 1
      }
      {
        name: PWC_PCS_3_LINK_BRINGUP_1
        module_name: PWC_PCS_3
        type: interrupt
        intr_type: IntrType.Event
        default_val: false
        incoming: true
        width: 1
      }
      {
        name: PWC_PCS_3_LINK_BRINGUP_2
        module_name: PWC_PCS_3
        type: interrupt
        intr_type: IntrType.Event
        default_val: false
        incoming: true
        width: 1
      }
      {
        name: PWC_PCS_3_LINK_BRINGUP_3
        module_name: PWC_PCS_3
        type: interrupt
        intr_type: IntrType.Event
        default_val: false
        incoming: true
        width: 1
      }
      {
        name: PWC_PCS_3_MSG_CTRL
        module_name: PWC_PCS_3
        type: interrupt
        intr_type: IntrType.Event
        default_val: false
        incoming: true
        width: 1
      }
      {
        name: PWC_PCS_3_PHY_STATUS
        module_name: PWC_PCS_3
        type: interrupt
        intr_type: IntrType.Event
        default_val: false
        incoming: true
        width: 1
      }
      {
        name: PWC_PCS_4_ALL_PORTS_STATUS
        module_name: PWC_PCS_4
        type: interrupt
        intr_type: IntrType.Event
        default_val: false
        incoming: true
        width: 1
      }
      {
        name: PWC_PCS_4_LINK_BRINGUP_0
        module_name: PWC_PCS_4
        type: interrupt
        intr_type: IntrType.Event
        default_val: false
        incoming: true
        width: 1
      }
      {
        name: PWC_PCS_4_LINK_BRINGUP_1
        module_name: PWC_PCS_4
        type: interrupt
        intr_type: IntrType.Event
        default_val: false
        incoming: true
        width: 1
      }
      {
        name: PWC_PCS_4_LINK_BRINGUP_2
        module_name: PWC_PCS_4
        type: interrupt
        intr_type: IntrType.Event
        default_val: false
        incoming: true
        width: 1
      }
      {
        name: PWC_PCS_4_LINK_BRINGUP_3
        module_name: PWC_PCS_4
        type: interrupt
        intr_type: IntrType.Event
        default_val: false
        incoming: true
        width: 1
      }
      {
        name: PWC_PCS_4_MSG_CTRL
        module_name: PWC_PCS_4
        type: interrupt
        intr_type: IntrType.Event
        default_val: false
        incoming: true
        width: 1
      }
      {
        name: PWC_PCS_4_PHY_STATUS
        module_name: PWC_PCS_4
        type: interrupt
        intr_type: IntrType.Event
        default_val: false
        incoming: true
        width: 1
      }
      {
        name: PWC_PCS_5_ALL_PORTS_STATUS
        module_name: PWC_PCS_5
        type: interrupt
        intr_type: IntrType.Event
        default_val: false
        incoming: true
        width: 1
      }
      {
        name: PWC_PCS_5_LINK_BRINGUP_0
        module_name: PWC_PCS_5
        type: interrupt
        intr_type: IntrType.Event
        default_val: false
        incoming: true
        width: 1
      }
      {
        name: PWC_PCS_5_LINK_BRINGUP_1
        module_name: PWC_PCS_5
        type: interrupt
        intr_type: IntrType.Event
        default_val: false
        incoming: true
        width: 1
      }
      {
        name: PWC_PCS_5_LINK_BRINGUP_2
        module_name: PWC_PCS_5
        type: interrupt
        intr_type: IntrType.Event
        default_val: false
        incoming: true
        width: 1
      }
      {
        name: PWC_PCS_5_LINK_BRINGUP_3
        module_name: PWC_PCS_5
        type: interrupt
        intr_type: IntrType.Event
        default_val: false
        incoming: true
        width: 1
      }
      {
        name: PWC_PCS_5_MSG_CTRL
        module_name: PWC_PCS_5
        type: interrupt
        intr_type: IntrType.Event
        default_val: false
        incoming: true
        width: 1
      }
      {
        name: PWC_PCS_5_PHY_STATUS
        module_name: PWC_PCS_5
        type: interrupt
        intr_type: IntrType.Event
        default_val: false
        incoming: true
        width: 1
      }
      {
        name: PWC_PCS_6_ALL_PORTS_STATUS
        module_name: PWC_PCS_6
        type: interrupt
        intr_type: IntrType.Event
        default_val: false
        incoming: true
        width: 1
      }
      {
        name: PWC_PCS_6_LINK_BRINGUP_0
        module_name: PWC_PCS_6
        type: interrupt
        intr_type: IntrType.Event
        default_val: false
        incoming: true
        width: 1
      }
      {
        name: PWC_PCS_6_LINK_BRINGUP_1
        module_name: PWC_PCS_6
        type: interrupt
        intr_type: IntrType.Event
        default_val: false
        incoming: true
        width: 1
      }
      {
        name: PWC_PCS_6_LINK_BRINGUP_2
        module_name: PWC_PCS_6
        type: interrupt
        intr_type: IntrType.Event
        default_val: false
        incoming: true
        width: 1
      }
      {
        name: PWC_PCS_6_LINK_BRINGUP_3
        module_name: PWC_PCS_6
        type: interrupt
        intr_type: IntrType.Event
        default_val: false
        incoming: true
        width: 1
      }
      {
        name: PWC_PCS_6_MSG_CTRL
        module_name: PWC_PCS_6
        type: interrupt
        intr_type: IntrType.Event
        default_val: false
        incoming: true
        width: 1
      }
      {
        name: PWC_PCS_6_PHY_STATUS
        module_name: PWC_PCS_6
        type: interrupt
        intr_type: IntrType.Event
        default_val: false
        incoming: true
        width: 1
      }
      {
        name: PWC_PCS_7_ALL_PORTS_STATUS
        module_name: PWC_PCS_7
        type: interrupt
        intr_type: IntrType.Event
        default_val: false
        incoming: true
        width: 1
      }
      {
        name: PWC_PCS_7_LINK_BRINGUP_0
        module_name: PWC_PCS_7
        type: interrupt
        intr_type: IntrType.Event
        default_val: false
        incoming: true
        width: 1
      }
      {
        name: PWC_PCS_7_LINK_BRINGUP_1
        module_name: PWC_PCS_7
        type: interrupt
        intr_type: IntrType.Event
        default_val: false
        incoming: true
        width: 1
      }
      {
        name: PWC_PCS_7_LINK_BRINGUP_2
        module_name: PWC_PCS_7
        type: interrupt
        intr_type: IntrType.Event
        default_val: false
        incoming: true
        width: 1
      }
      {
        name: PWC_PCS_7_LINK_BRINGUP_3
        module_name: PWC_PCS_7
        type: interrupt
        intr_type: IntrType.Event
        default_val: false
        incoming: true
        width: 1
      }
      {
        name: PWC_PCS_7_MSG_CTRL
        module_name: PWC_PCS_7
        type: interrupt
        intr_type: IntrType.Event
        default_val: false
        incoming: true
        width: 1
      }
      {
        name: PWC_PCS_7_PHY_STATUS
        module_name: PWC_PCS_7
        type: interrupt
        intr_type: IntrType.Event
        default_val: false
        incoming: true
        width: 1
      }
      {
        name: PWC_HDR_IPI_FROM_PWC_0
        module_name: PWC_HDR
        type: interrupt
        intr_type: IntrType.Event
        default_val: false
        incoming: true
        width: 1
      }
      {
        name: PWC_HDR_IPI_FROM_PWC_1
        module_name: PWC_HDR
        type: interrupt
        intr_type: IntrType.Event
        default_val: false
        incoming: true
        width: 1
      }
      {
        name: PWC_HDR_IPI_FROM_PWC_2
        module_name: PWC_HDR
        type: interrupt
        intr_type: IntrType.Event
        default_val: false
        incoming: true
        width: 1
      }
      {
        name: PWC_HDR_IPI_FROM_ROT
        module_name: PWC_HDR
        type: interrupt
        intr_type: IntrType.Event
        default_val: false
        incoming: true
        width: 1
      }
      {
        name: PWC_HDR_IPI_FROM_MIO
        module_name: PWC_HDR
        type: interrupt
        intr_type: IntrType.Event
        default_val: false
        incoming: true
        width: 1
      }
      {
        name: PWC_HDR_IPI_FROM_DUC
        module_name: PWC_HDR
        type: interrupt
        intr_type: IntrType.Event
        default_val: false
        incoming: true
        width: 1
      }
    ]
  }
  exported_clks: {}
  wakeups:
  [
    {
      name: wkup_req
      width: "1"
      module: aon_timer_aon
    }
  ]
  reset_requests:
  {
    peripheral:
    [
      {
        name: aon_timer_rst_req
        width: "1"
        module: aon_timer_aon
        desc: watchdog reset requestt
      }
    ]
    int:
    [
      {
        name: MainPwr
        desc: main power glitch reset request
        module: pwrmgr_aon
      }
      {
        name: Esc
        desc: escalation reset request
        module: alert_handler
      }
    ]
    debug:
    [
      {
        name: Ndm
        desc: non-debug-module reset request
        module: rv_dm
      }
    ]
  }
  interrupt_module:
  [
    gpio
    rv_timer
    aon_timer_aon
    soc_proxy
    dma
    mbx0
    mbx1
    mbx2
    mbx3
    mbx4
    mbx5
  ]
  interrupt:
  [
    {
      name: gpio_gpio
      width: 32
      type: interrupt
      module_name: gpio
      intr_type: IntrType.Event
      default_val: false
      incoming: false
    }
    {
      name: rv_timer_timer_expired_hart0_timer0
      width: 1
      type: interrupt
      module_name: rv_timer
      intr_type: IntrType.Event
      default_val: false
      incoming: false
    }
    {
      name: aon_timer_aon_wkup_timer_expired
      width: 1
      type: interrupt
      module_name: aon_timer_aon
      intr_type: IntrType.Event
      default_val: false
      incoming: false
    }
    {
      name: aon_timer_aon_wdog_timer_bark
      width: 1
      type: interrupt
      module_name: aon_timer_aon
      intr_type: IntrType.Event
      default_val: false
      incoming: false
    }
    {
      name: soc_proxy_external
      width: 32
      type: interrupt
      module_name: soc_proxy
      intr_type: IntrType.Event
      default_val: false
      incoming: false
    }
    {
      name: dma_dma_done
      width: 1
      type: interrupt
      module_name: dma
      intr_type: IntrType.Status
      default_val: false
      incoming: false
    }
    {
      name: dma_dma_chunk_done
      width: 1
      type: interrupt
      module_name: dma
      intr_type: IntrType.Status
      default_val: false
      incoming: false
    }
    {
      name: dma_dma_error
      width: 1
      type: interrupt
      module_name: dma
      intr_type: IntrType.Status
      default_val: false
      incoming: false
    }
    {
      name: mbx0_mbx_ready
      width: 1
      type: interrupt
      module_name: mbx0
      intr_type: IntrType.Event
      default_val: false
      incoming: false
    }
    {
      name: mbx0_mbx_abort
      width: 1
      type: interrupt
      module_name: mbx0
      intr_type: IntrType.Event
      default_val: false
      incoming: false
    }
    {
      name: mbx0_mbx_error
      width: 1
      type: interrupt
      module_name: mbx0
      intr_type: IntrType.Event
      default_val: false
      incoming: false
    }
    {
      name: mbx1_mbx_ready
      width: 1
      type: interrupt
      module_name: mbx1
      intr_type: IntrType.Event
      default_val: false
      incoming: false
    }
    {
      name: mbx1_mbx_abort
      width: 1
      type: interrupt
      module_name: mbx1
      intr_type: IntrType.Event
      default_val: false
      incoming: false
    }
    {
      name: mbx1_mbx_error
      width: 1
      type: interrupt
      module_name: mbx1
      intr_type: IntrType.Event
      default_val: false
      incoming: false
    }
    {
      name: mbx2_mbx_ready
      width: 1
      type: interrupt
      module_name: mbx2
      intr_type: IntrType.Event
      default_val: false
      incoming: false
    }
    {
      name: mbx2_mbx_abort
      width: 1
      type: interrupt
      module_name: mbx2
      intr_type: IntrType.Event
      default_val: false
      incoming: false
    }
    {
      name: mbx2_mbx_error
      width: 1
      type: interrupt
      module_name: mbx2
      intr_type: IntrType.Event
      default_val: false
      incoming: false
    }
    {
      name: mbx3_mbx_ready
      width: 1
      type: interrupt
      module_name: mbx3
      intr_type: IntrType.Event
      default_val: false
      incoming: false
    }
    {
      name: mbx3_mbx_abort
      width: 1
      type: interrupt
      module_name: mbx3
      intr_type: IntrType.Event
      default_val: false
      incoming: false
    }
    {
      name: mbx3_mbx_error
      width: 1
      type: interrupt
      module_name: mbx3
      intr_type: IntrType.Event
      default_val: false
      incoming: false
    }
    {
      name: mbx4_mbx_ready
      width: 1
      type: interrupt
      module_name: mbx4
      intr_type: IntrType.Event
      default_val: false
      incoming: false
    }
    {
      name: mbx4_mbx_abort
      width: 1
      type: interrupt
      module_name: mbx4
      intr_type: IntrType.Event
      default_val: false
      incoming: false
    }
    {
      name: mbx4_mbx_error
      width: 1
      type: interrupt
      module_name: mbx4
      intr_type: IntrType.Event
      default_val: false
      incoming: false
    }
    {
      name: mbx5_mbx_ready
      width: 1
      type: interrupt
      module_name: mbx5
      intr_type: IntrType.Event
      default_val: false
      incoming: false
    }
    {
      name: mbx5_mbx_abort
      width: 1
      type: interrupt
      module_name: mbx5
      intr_type: IntrType.Event
      default_val: false
      incoming: false
    }
    {
      name: mbx5_mbx_error
      width: 1
      type: interrupt
      module_name: mbx5
      intr_type: IntrType.Event
      default_val: false
      incoming: false
    }
    {
      name: PWC_LTEU_SOC_HOT
      module_name: PWC_LTEU
      type: interrupt
      intr_type: IntrType.Event
      default_val: false
      incoming: true
      width: 1
    }
    {
      name: PWC_LTEU_FW_TRIP
      module_name: PWC_LTEU
      type: interrupt
      intr_type: IntrType.Event
      default_val: false
      incoming: true
      width: 1
    }
    {
      name: PWC_LTEU_CAT_TRIP
      module_name: PWC_LTEU
      type: interrupt
      intr_type: IntrType.Event
      default_val: false
      incoming: true
      width: 1
    }
    {
      name: LIO_GRP_A_IBEX_IRQ
      module_name: LIO_GRP_A
      type: interrupt
      intr_type: IntrType.Event
      default_val: false
      incoming: true
      width: 1
    }
    {
      name: LIO_GRP_B_IBEX_IRQ
      module_name: LIO_GRP_B
      type: interrupt
      intr_type: IntrType.Event
      default_val: false
      incoming: true
      width: 1
    }
    {
      name: LIO_GRP_C_IBEX_IRQ
      module_name: LIO_GRP_C
      type: interrupt
      intr_type: IntrType.Event
      default_val: false
      incoming: true
      width: 1
    }
    {
      name: PWC_DVFS_SocDpaFsmstatus0
      module_name: PWC_DVFS
      type: interrupt
      intr_type: IntrType.Event
      default_val: false
      incoming: true
      width: 1
    }
    {
      name: PWC_DVFS_SocDpaFsmstatus1
      module_name: PWC_DVFS
      type: interrupt
      intr_type: IntrType.Event
      default_val: false
      incoming: true
      width: 1
    }
    {
      name: PWC_DVFS_SocDpaFsmstatus2
      module_name: PWC_DVFS
      type: interrupt
      intr_type: IntrType.Event
      default_val: false
      incoming: true
      width: 1
    }
    {
      name: PWC_DVFS_SocDpaFsmstatus3
      module_name: PWC_DVFS
      type: interrupt
      intr_type: IntrType.Event
      default_val: false
      incoming: true
      width: 1
    }
    {
      name: PWC_DVFS_SocDpaFsmstatus4
      module_name: PWC_DVFS
      type: interrupt
      intr_type: IntrType.Event
      default_val: false
      incoming: true
      width: 1
    }
    {
      name: PWC_DVFS_TargetCmdAVS0
      module_name: PWC_DVFS
      type: interrupt
      intr_type: IntrType.Event
      default_val: false
      incoming: true
      width: 1
    }
    {
      name: PWC_DVFS_TargetCmdAVS1
      module_name: PWC_DVFS
      type: interrupt
      intr_type: IntrType.Event
      default_val: false
      incoming: true
      width: 1
    }
    {
      name: PWC_DVFS_TargetCmdAVS2
      module_name: PWC_DVFS
      type: interrupt
      intr_type: IntrType.Event
      default_val: false
      incoming: true
      width: 1
    }
    {
      name: PWC_DVFS_TargetCmdAVS3
      module_name: PWC_DVFS
      type: interrupt
      intr_type: IntrType.Event
      default_val: false
      incoming: true
      width: 1
    }
    {
      name: PWC_DVFS_TargetCmdAVS4
      module_name: PWC_DVFS
      type: interrupt
      intr_type: IntrType.Event
      default_val: false
      incoming: true
      width: 1
    }
    {
      name: PWC_DVFS_TargetCmdAVS5
      module_name: PWC_DVFS
      type: interrupt
      intr_type: IntrType.Event
      default_val: false
      incoming: true
      width: 1
    }
    {
      name: PWC_DVFS_TargetCmdAVS6
      module_name: PWC_DVFS
      type: interrupt
      intr_type: IntrType.Event
      default_val: false
      incoming: true
      width: 1
    }
    {
      name: PWC_DVFS_TargetCmdAVS7
      module_name: PWC_DVFS
      type: interrupt
      intr_type: IntrType.Event
      default_val: false
      incoming: true
      width: 1
    }
    {
      name: PWC_DVFS_TargetCmdAVS8
      module_name: PWC_DVFS
      type: interrupt
      intr_type: IntrType.Event
      default_val: false
      incoming: true
      width: 1
    }
    {
      name: PWC_DVFS_TargetCmdAVS9
      module_name: PWC_DVFS
      type: interrupt
      intr_type: IntrType.Event
      default_val: false
      incoming: true
      width: 1
    }
    {
      name: PWC_DVFS_TargetCmdAVS10
      module_name: PWC_DVFS
      type: interrupt
      intr_type: IntrType.Event
      default_val: false
      incoming: true
      width: 1
    }
    {
      name: PWC_DVFS_TargetCmdAVS11
      module_name: PWC_DVFS
      type: interrupt
      intr_type: IntrType.Event
      default_val: false
      incoming: true
      width: 1
    }
    {
      name: PWC_DVFS_TargetCmdAVS12
      module_name: PWC_DVFS
      type: interrupt
      intr_type: IntrType.Event
      default_val: false
      incoming: true
      width: 1
    }
    {
      name: PWC_DVFS_TargetCmdAVS13
      module_name: PWC_DVFS
      type: interrupt
      intr_type: IntrType.Event
      default_val: false
      incoming: true
      width: 1
    }
    {
      name: PWC_AVS_AVS_ERROR_0
      module_name: PWC_AVS
      type: interrupt
      intr_type: IntrType.Event
      default_val: false
      incoming: true
      width: 1
    }
    {
      name: PWC_AVS_AVS_ERROR_1
      module_name: PWC_AVS
      type: interrupt
      intr_type: IntrType.Event
      default_val: false
      incoming: true
      width: 1
    }
    {
      name: PWC_AVS_AVS_ERROR_2
      module_name: PWC_AVS
      type: interrupt
      intr_type: IntrType.Event
      default_val: false
      incoming: true
      width: 1
    }
    {
      name: PWC_AVS_AVS_ERROR_3
      module_name: PWC_AVS
      type: interrupt
      intr_type: IntrType.Event
      default_val: false
      incoming: true
      width: 1
    }
    {
      name: PWC_AVS_AVS_ERROR_4
      module_name: PWC_AVS
      type: interrupt
      intr_type: IntrType.Event
      default_val: false
      incoming: true
      width: 1
    }
    {
      name: PWC_AVS_AVS_ERROR_5
      module_name: PWC_AVS
      type: interrupt
      intr_type: IntrType.Event
      default_val: false
      incoming: true
      width: 1
    }
    {
      name: PWC_AVS_AVS_ERROR_6
      module_name: PWC_AVS
      type: interrupt
      intr_type: IntrType.Event
      default_val: false
      incoming: true
      width: 1
    }
    {
      name: PWC_AVS_AVS_ERROR_7
      module_name: PWC_AVS
      type: interrupt
      intr_type: IntrType.Event
      default_val: false
      incoming: true
      width: 1
    }
    {
      name: PWC_AVS_AVS_ERROR_8
      module_name: PWC_AVS
      type: interrupt
      intr_type: IntrType.Event
      default_val: false
      incoming: true
      width: 1
    }
    {
      name: PWC_AVS_AVS_ERROR_9
      module_name: PWC_AVS
      type: interrupt
      intr_type: IntrType.Event
      default_val: false
      incoming: true
      width: 1
    }
    {
      name: PWC_AVS_AVS_ERROR_10
      module_name: PWC_AVS
      type: interrupt
      intr_type: IntrType.Event
      default_val: false
      incoming: true
      width: 1
    }
    {
      name: PWC_AVS_AVS_ERROR_11
      module_name: PWC_AVS
      type: interrupt
      intr_type: IntrType.Event
      default_val: false
      incoming: true
      width: 1
    }
    {
      name: PWC_AVS_AVS_ERROR_12
      module_name: PWC_AVS
      type: interrupt
      intr_type: IntrType.Event
      default_val: false
      incoming: true
      width: 1
    }
    {
      name: PWC_AVS_AVS_ERROR_13
      module_name: PWC_AVS
      type: interrupt
      intr_type: IntrType.Event
      default_val: false
      incoming: true
      width: 1
    }
    {
      name: PWC_AVS_AVS_ERROR_14
      module_name: PWC_AVS
      type: interrupt
      intr_type: IntrType.Event
      default_val: false
      incoming: true
      width: 1
    }
    {
      name: PWC_AVS_AVS_ERROR_15
      module_name: PWC_AVS
      type: interrupt
      intr_type: IntrType.Event
      default_val: false
      incoming: true
      width: 1
    }
    {
      name: PWC_AVS_AVS_ERROR_16
      module_name: PWC_AVS
      type: interrupt
      intr_type: IntrType.Event
      default_val: false
      incoming: true
      width: 1
    }
    {
      name: PWC_AVS_AVS_ERROR_17
      module_name: PWC_AVS
      type: interrupt
      intr_type: IntrType.Event
      default_val: false
      incoming: true
      width: 1
    }
    {
      name: PWC_AVS_AVS_ERROR_18
      module_name: PWC_AVS
      type: interrupt
      intr_type: IntrType.Event
      default_val: false
      incoming: true
      width: 1
    }
    {
      name: PWC_AVS_AVS_ERROR_19
      module_name: PWC_AVS
      type: interrupt
      intr_type: IntrType.Event
      default_val: false
      incoming: true
      width: 1
    }
    {
      name: PWC_AVS_AVS_ERROR_20
      module_name: PWC_AVS
      type: interrupt
      intr_type: IntrType.Event
      default_val: false
      incoming: true
      width: 1
    }
    {
      name: PWC_AVS_AVS_RESPONSE_TO_FW_0
      module_name: PWC_AVS
      type: interrupt
      intr_type: IntrType.Event
      default_val: false
      incoming: true
      width: 1
    }
    {
      name: PWC_AVS_AVS_RESPONSE_TO_FW_1
      module_name: PWC_AVS
      type: interrupt
      intr_type: IntrType.Event
      default_val: false
      incoming: true
      width: 1
    }
    {
      name: PWC_AVS_AVS_RESPONSE_TO_FW_2
      module_name: PWC_AVS
      type: interrupt
      intr_type: IntrType.Event
      default_val: false
      incoming: true
      width: 1
    }
    {
      name: PWC_AVS_AVS_RESPONSE_TO_FW_3
      module_name: PWC_AVS
      type: interrupt
      intr_type: IntrType.Event
      default_val: false
      incoming: true
      width: 1
    }
    {
      name: PWC_AVS_AVS_RESPONSE_TO_FW_4
      module_name: PWC_AVS
      type: interrupt
      intr_type: IntrType.Event
      default_val: false
      incoming: true
      width: 1
    }
    {
      name: PWC_AVS_AVS_RESPONSE_TO_FW_5
      module_name: PWC_AVS
      type: interrupt
      intr_type: IntrType.Event
      default_val: false
      incoming: true
      width: 1
    }
    {
      name: PWC_AVS_AVS_RESPONSE_TO_FW_6
      module_name: PWC_AVS
      type: interrupt
      intr_type: IntrType.Event
      default_val: false
      incoming: true
      width: 1
    }
    {
      name: PWC_AVS_AVS_RESPONSE_TO_FW_7
      module_name: PWC_AVS
      type: interrupt
      intr_type: IntrType.Event
      default_val: false
      incoming: true
      width: 1
    }
    {
      name: PWC_AVS_AVS_RESPONSE_TO_FW_8
      module_name: PWC_AVS
      type: interrupt
      intr_type: IntrType.Event
      default_val: false
      incoming: true
      width: 1
    }
    {
      name: PWC_AVS_AVS_RESPONSE_TO_FW_9
      module_name: PWC_AVS
      type: interrupt
      intr_type: IntrType.Event
      default_val: false
      incoming: true
      width: 1
    }
    {
      name: PWC_AVS_AVS_RESPONSE_TO_FW_10
      module_name: PWC_AVS
      type: interrupt
      intr_type: IntrType.Event
      default_val: false
      incoming: true
      width: 1
    }
    {
      name: PWC_AVS_AVS_RESPONSE_TO_FW_11
      module_name: PWC_AVS
      type: interrupt
      intr_type: IntrType.Event
      default_val: false
      incoming: true
      width: 1
    }
    {
      name: PWC_AVS_AVS_RESPONSE_TO_FW_12
      module_name: PWC_AVS
      type: interrupt
      intr_type: IntrType.Event
      default_val: false
      incoming: true
      width: 1
    }
    {
      name: PWC_AVS_AVS_RESPONSE_TO_FW_13
      module_name: PWC_AVS
      type: interrupt
      intr_type: IntrType.Event
      default_val: false
      incoming: true
      width: 1
    }
    {
      name: PWC_AVS_AVS_RESPONSE_TO_FW_14
      module_name: PWC_AVS
      type: interrupt
      intr_type: IntrType.Event
      default_val: false
      incoming: true
      width: 1
    }
    {
      name: PWC_AVS_AVS_RESPONSE_TO_FW_15
      module_name: PWC_AVS
      type: interrupt
      intr_type: IntrType.Event
      default_val: false
      incoming: true
      width: 1
    }
    {
      name: PWC_AVS_AVS_RESPONSE_TO_FW_16
      module_name: PWC_AVS
      type: interrupt
      intr_type: IntrType.Event
      default_val: false
      incoming: true
      width: 1
    }
    {
      name: PWC_AVS_AVS_RESPONSE_TO_FW_17
      module_name: PWC_AVS
      type: interrupt
      intr_type: IntrType.Event
      default_val: false
      incoming: true
      width: 1
    }
    {
      name: PWC_AVS_AVS_RESPONSE_TO_FW_18
      module_name: PWC_AVS
      type: interrupt
      intr_type: IntrType.Event
      default_val: false
      incoming: true
      width: 1
    }
    {
      name: PWC_AVS_AVS_RESPONSE_TO_FW_19
      module_name: PWC_AVS
      type: interrupt
      intr_type: IntrType.Event
      default_val: false
      incoming: true
      width: 1
    }
    {
      name: PWC_AVS_AVS_RESPONSE_TO_FW_20
      module_name: PWC_AVS
      type: interrupt
      intr_type: IntrType.Event
      default_val: false
      incoming: true
      width: 1
    }
    {
      name: PWC_AVS_AVS_RESPONSE_TO_FW_21
      module_name: PWC_AVS
      type: interrupt
      intr_type: IntrType.Event
      default_val: false
      incoming: true
      width: 1
    }
    {
      name: PWC_AVS_AVS_RESPONSE_TO_FW_22
      module_name: PWC_AVS
      type: interrupt
      intr_type: IntrType.Event
      default_val: false
      incoming: true
      width: 1
    }
    {
      name: PWC_AVS_AVS_RESPONSE_TO_FW_23
      module_name: PWC_AVS
      type: interrupt
      intr_type: IntrType.Event
      default_val: false
      incoming: true
      width: 1
    }
    {
      name: PWC_AVS_AVS_RESPONSE_TO_FW_24
      module_name: PWC_AVS
      type: interrupt
      intr_type: IntrType.Event
      default_val: false
      incoming: true
      width: 1
    }
    {
      name: PWC_AVS_AVS_RESPONSE_TO_FW_25
      module_name: PWC_AVS
      type: interrupt
      intr_type: IntrType.Event
      default_val: false
      incoming: true
      width: 1
    }
    {
      name: PWC_AVS_AVS_RESPONSE_TO_FW_26
      module_name: PWC_AVS
      type: interrupt
      intr_type: IntrType.Event
      default_val: false
      incoming: true
      width: 1
    }
    {
      name: PWC_AVS_AVS_RESPONSE_TO_FW_27
      module_name: PWC_AVS
      type: interrupt
      intr_type: IntrType.Event
      default_val: false
      incoming: true
      width: 1
    }
    {
      name: PWC_AVS_AVS_RESPONSE_TO_FW_28
      module_name: PWC_AVS
      type: interrupt
      intr_type: IntrType.Event
      default_val: false
      incoming: true
      width: 1
    }
    {
      name: PWC_BCAST_C_STATE_ENTRY
      module_name: PWC_BCAST
      type: interrupt
      intr_type: IntrType.Event
      default_val: false
      incoming: true
      width: 1
    }
    {
      name: PWC_BCAST_C_STATE_EXIT
      module_name: PWC_BCAST
      type: interrupt
      intr_type: IntrType.Event
      default_val: false
      incoming: true
      width: 1
    }
    {
      name: PWC_BCAST_DPA_IDLE_ENTRY
      module_name: PWC_BCAST
      type: interrupt
      intr_type: IntrType.Event
      default_val: false
      incoming: true
      width: 1
    }
    {
      name: PWC_BCAST_DPA_IDLE_EXIT
      module_name: PWC_BCAST
      type: interrupt
      intr_type: IntrType.Event
      default_val: false
      incoming: true
      width: 1
    }
    {
      name: PWC_CCS_0_PWR_VIRUS_LVL_REQ
      module_name: PWC_CCS_0
      type: interrupt
      intr_type: IntrType.Event
      default_val: false
      incoming: true
      width: 1
    }
    {
      name: PWC_CCS_1_PWR_VIRUS_LVL_REQ
      module_name: PWC_CCS_1
      type: interrupt
      intr_type: IntrType.Event
      default_val: false
      incoming: true
      width: 1
    }
    {
      name: PWC_CCS_2_PWR_VIRUS_LVL_REQ
      module_name: PWC_CCS_2
      type: interrupt
      intr_type: IntrType.Event
      default_val: false
      incoming: true
      width: 1
    }
    {
      name: PWC_CCS_3_PWR_VIRUS_LVL_REQ
      module_name: PWC_CCS_3
      type: interrupt
      intr_type: IntrType.Event
      default_val: false
      incoming: true
      width: 1
    }
    {
      name: PWC_CCS_4_PWR_VIRUS_LVL_REQ
      module_name: PWC_CCS_4
      type: interrupt
      intr_type: IntrType.Event
      default_val: false
      incoming: true
      width: 1
    }
    {
      name: PWC_CCS_5_PWR_VIRUS_LVL_REQ
      module_name: PWC_CCS_5
      type: interrupt
      intr_type: IntrType.Event
      default_val: false
      incoming: true
      width: 1
    }
    {
      name: PWC_CCS_6_PWR_VIRUS_LVL_REQ
      module_name: PWC_CCS_6
      type: interrupt
      intr_type: IntrType.Event
      default_val: false
      incoming: true
      width: 1
    }
    {
      name: PWC_CCS_7_PWR_VIRUS_LVL_REQ
      module_name: PWC_CCS_7
      type: interrupt
      intr_type: IntrType.Event
      default_val: false
      incoming: true
      width: 1
    }
    {
      name: PWC_CCS_0_DVFS_FSM
      module_name: PWC_CCS_0
      type: interrupt
      intr_type: IntrType.Event
      default_val: false
      incoming: true
      width: 1
    }
    {
      name: PWC_CCS_1_DVFS_FSM
      module_name: PWC_CCS_1
      type: interrupt
      intr_type: IntrType.Event
      default_val: false
      incoming: true
      width: 1
    }
    {
      name: PWC_CCS_2_DVFS_FSM
      module_name: PWC_CCS_2
      type: interrupt
      intr_type: IntrType.Event
      default_val: false
      incoming: true
      width: 1
    }
    {
      name: PWC_CCS_3_DVFS_FSM
      module_name: PWC_CCS_3
      type: interrupt
      intr_type: IntrType.Event
      default_val: false
      incoming: true
      width: 1
    }
    {
      name: PWC_CCS_4_DVFS_FSM
      module_name: PWC_CCS_4
      type: interrupt
      intr_type: IntrType.Event
      default_val: false
      incoming: true
      width: 1
    }
    {
      name: PWC_CCS_5_DVFS_FSM
      module_name: PWC_CCS_5
      type: interrupt
      intr_type: IntrType.Event
      default_val: false
      incoming: true
      width: 1
    }
    {
      name: PWC_CCS_6_DVFS_FSM
      module_name: PWC_CCS_6
      type: interrupt
      intr_type: IntrType.Event
      default_val: false
      incoming: true
      width: 1
    }
    {
      name: PWC_CCS_7_DVFS_FSM
      module_name: PWC_CCS_7
      type: interrupt
      intr_type: IntrType.Event
      default_val: false
      incoming: true
      width: 1
    }
    {
      name: PWC_HMS_East_STATUS
      module_name: PWC_HMS
      type: interrupt
      intr_type: IntrType.Event
      default_val: false
      incoming: true
      width: 1
    }
    {
      name: PWC_HMS_WEST_STATUS
      module_name: PWC_HMS
      type: interrupt
      intr_type: IntrType.Event
      default_val: false
      incoming: true
      width: 1
    }
    {
      name: PWC_PCS_0_ALL_PORTS_STATUS
      module_name: PWC_PCS_0
      type: interrupt
      intr_type: IntrType.Event
      default_val: false
      incoming: true
      width: 1
    }
    {
      name: PWC_PCS_0_LINK_BRINGUP_0
      module_name: PWC_PCS_0
      type: interrupt
      intr_type: IntrType.Event
      default_val: false
      incoming: true
      width: 1
    }
    {
      name: PWC_PCS_0_LINK_BRINGUP_1
      module_name: PWC_PCS_0
      type: interrupt
      intr_type: IntrType.Event
      default_val: false
      incoming: true
      width: 1
    }
    {
      name: PWC_PCS_0_LINK_BRINGUP_2
      module_name: PWC_PCS_0
      type: interrupt
      intr_type: IntrType.Event
      default_val: false
      incoming: true
      width: 1
    }
    {
      name: PWC_PCS_0_LINK_BRINGUP_3
      module_name: PWC_PCS_0
      type: interrupt
      intr_type: IntrType.Event
      default_val: false
      incoming: true
      width: 1
    }
    {
      name: PWC_PCS_0_MSG_CTRL
      module_name: PWC_PCS_0
      type: interrupt
      intr_type: IntrType.Event
      default_val: false
      incoming: true
      width: 1
    }
    {
      name: PWC_PCS_0_PHY_STATUS
      module_name: PWC_PCS_0
      type: interrupt
      intr_type: IntrType.Event
      default_val: false
      incoming: true
      width: 1
    }
    {
      name: PWC_PCS_1_ALL_PORTS_STATUS
      module_name: PWC_PCS_1
      type: interrupt
      intr_type: IntrType.Event
      default_val: false
      incoming: true
      width: 1
    }
    {
      name: PWC_PCS_1_LINK_BRINGUP_0
      module_name: PWC_PCS_1
      type: interrupt
      intr_type: IntrType.Event
      default_val: false
      incoming: true
      width: 1
    }
    {
      name: PWC_PCS_1_LINK_BRINGUP_1
      module_name: PWC_PCS_1
      type: interrupt
      intr_type: IntrType.Event
      default_val: false
      incoming: true
      width: 1
    }
    {
      name: PWC_PCS_1_LINK_BRINGUP_2
      module_name: PWC_PCS_1
      type: interrupt
      intr_type: IntrType.Event
      default_val: false
      incoming: true
      width: 1
    }
    {
      name: PWC_PCS_1_LINK_BRINGUP_3
      module_name: PWC_PCS_1
      type: interrupt
      intr_type: IntrType.Event
      default_val: false
      incoming: true
      width: 1
    }
    {
      name: PWC_PCS_1_MSG_CTRL
      module_name: PWC_PCS_1
      type: interrupt
      intr_type: IntrType.Event
      default_val: false
      incoming: true
      width: 1
    }
    {
      name: PWC_PCS_1_PHY_STATUS
      module_name: PWC_PCS_1
      type: interrupt
      intr_type: IntrType.Event
      default_val: false
      incoming: true
      width: 1
    }
    {
      name: PWC_PCS_2_ALL_PORTS_STATUS
      module_name: PWC_PCS_2
      type: interrupt
      intr_type: IntrType.Event
      default_val: false
      incoming: true
      width: 1
    }
    {
      name: PWC_PCS_2_LINK_BRINGUP_0
      module_name: PWC_PCS_2
      type: interrupt
      intr_type: IntrType.Event
      default_val: false
      incoming: true
      width: 1
    }
    {
      name: PWC_PCS_2_LINK_BRINGUP_1
      module_name: PWC_PCS_2
      type: interrupt
      intr_type: IntrType.Event
      default_val: false
      incoming: true
      width: 1
    }
    {
      name: PWC_PCS_2_LINK_BRINGUP_2
      module_name: PWC_PCS_2
      type: interrupt
      intr_type: IntrType.Event
      default_val: false
      incoming: true
      width: 1
    }
    {
      name: PWC_PCS_2_LINK_BRINGUP_3
      module_name: PWC_PCS_2
      type: interrupt
      intr_type: IntrType.Event
      default_val: false
      incoming: true
      width: 1
    }
    {
      name: PWC_PCS_2_MSG_CTRL
      module_name: PWC_PCS_2
      type: interrupt
      intr_type: IntrType.Event
      default_val: false
      incoming: true
      width: 1
    }
    {
      name: PWC_PCS_2_PHY_STATUS
      module_name: PWC_PCS_2
      type: interrupt
      intr_type: IntrType.Event
      default_val: false
      incoming: true
      width: 1
    }
    {
      name: PWC_PCS_3_ALL_PORTS_STATUS
      module_name: PWC_PCS_3
      type: interrupt
      intr_type: IntrType.Event
      default_val: false
      incoming: true
      width: 1
    }
    {
      name: PWC_PCS_3_LINK_BRINGUP_0
      module_name: PWC_PCS_3
      type: interrupt
      intr_type: IntrType.Event
      default_val: false
      incoming: true
      width: 1
    }
    {
      name: PWC_PCS_3_LINK_BRINGUP_1
      module_name: PWC_PCS_3
      type: interrupt
      intr_type: IntrType.Event
      default_val: false
      incoming: true
      width: 1
    }
    {
      name: PWC_PCS_3_LINK_BRINGUP_2
      module_name: PWC_PCS_3
      type: interrupt
      intr_type: IntrType.Event
      default_val: false
      incoming: true
      width: 1
    }
    {
      name: PWC_PCS_3_LINK_BRINGUP_3
      module_name: PWC_PCS_3
      type: interrupt
      intr_type: IntrType.Event
      default_val: false
      incoming: true
      width: 1
    }
    {
      name: PWC_PCS_3_MSG_CTRL
      module_name: PWC_PCS_3
      type: interrupt
      intr_type: IntrType.Event
      default_val: false
      incoming: true
      width: 1
    }
    {
      name: PWC_PCS_3_PHY_STATUS
      module_name: PWC_PCS_3
      type: interrupt
      intr_type: IntrType.Event
      default_val: false
      incoming: true
      width: 1
    }
    {
      name: PWC_PCS_4_ALL_PORTS_STATUS
      module_name: PWC_PCS_4
      type: interrupt
      intr_type: IntrType.Event
      default_val: false
      incoming: true
      width: 1
    }
    {
      name: PWC_PCS_4_LINK_BRINGUP_0
      module_name: PWC_PCS_4
      type: interrupt
      intr_type: IntrType.Event
      default_val: false
      incoming: true
      width: 1
    }
    {
      name: PWC_PCS_4_LINK_BRINGUP_1
      module_name: PWC_PCS_4
      type: interrupt
      intr_type: IntrType.Event
      default_val: false
      incoming: true
      width: 1
    }
    {
      name: PWC_PCS_4_LINK_BRINGUP_2
      module_name: PWC_PCS_4
      type: interrupt
      intr_type: IntrType.Event
      default_val: false
      incoming: true
      width: 1
    }
    {
      name: PWC_PCS_4_LINK_BRINGUP_3
      module_name: PWC_PCS_4
      type: interrupt
      intr_type: IntrType.Event
      default_val: false
      incoming: true
      width: 1
    }
    {
      name: PWC_PCS_4_MSG_CTRL
      module_name: PWC_PCS_4
      type: interrupt
      intr_type: IntrType.Event
      default_val: false
      incoming: true
      width: 1
    }
    {
      name: PWC_PCS_4_PHY_STATUS
      module_name: PWC_PCS_4
      type: interrupt
      intr_type: IntrType.Event
      default_val: false
      incoming: true
      width: 1
    }
    {
      name: PWC_PCS_5_ALL_PORTS_STATUS
      module_name: PWC_PCS_5
      type: interrupt
      intr_type: IntrType.Event
      default_val: false
      incoming: true
      width: 1
    }
    {
      name: PWC_PCS_5_LINK_BRINGUP_0
      module_name: PWC_PCS_5
      type: interrupt
      intr_type: IntrType.Event
      default_val: false
      incoming: true
      width: 1
    }
    {
      name: PWC_PCS_5_LINK_BRINGUP_1
      module_name: PWC_PCS_5
      type: interrupt
      intr_type: IntrType.Event
      default_val: false
      incoming: true
      width: 1
    }
    {
      name: PWC_PCS_5_LINK_BRINGUP_2
      module_name: PWC_PCS_5
      type: interrupt
      intr_type: IntrType.Event
      default_val: false
      incoming: true
      width: 1
    }
    {
      name: PWC_PCS_5_LINK_BRINGUP_3
      module_name: PWC_PCS_5
      type: interrupt
      intr_type: IntrType.Event
      default_val: false
      incoming: true
      width: 1
    }
    {
      name: PWC_PCS_5_MSG_CTRL
      module_name: PWC_PCS_5
      type: interrupt
      intr_type: IntrType.Event
      default_val: false
      incoming: true
      width: 1
    }
    {
      name: PWC_PCS_5_PHY_STATUS
      module_name: PWC_PCS_5
      type: interrupt
      intr_type: IntrType.Event
      default_val: false
      incoming: true
      width: 1
    }
    {
      name: PWC_PCS_6_ALL_PORTS_STATUS
      module_name: PWC_PCS_6
      type: interrupt
      intr_type: IntrType.Event
      default_val: false
      incoming: true
      width: 1
    }
    {
      name: PWC_PCS_6_LINK_BRINGUP_0
      module_name: PWC_PCS_6
      type: interrupt
      intr_type: IntrType.Event
      default_val: false
      incoming: true
      width: 1
    }
    {
      name: PWC_PCS_6_LINK_BRINGUP_1
      module_name: PWC_PCS_6
      type: interrupt
      intr_type: IntrType.Event
      default_val: false
      incoming: true
      width: 1
    }
    {
      name: PWC_PCS_6_LINK_BRINGUP_2
      module_name: PWC_PCS_6
      type: interrupt
      intr_type: IntrType.Event
      default_val: false
      incoming: true
      width: 1
    }
    {
      name: PWC_PCS_6_LINK_BRINGUP_3
      module_name: PWC_PCS_6
      type: interrupt
      intr_type: IntrType.Event
      default_val: false
      incoming: true
      width: 1
    }
    {
      name: PWC_PCS_6_MSG_CTRL
      module_name: PWC_PCS_6
      type: interrupt
      intr_type: IntrType.Event
      default_val: false
      incoming: true
      width: 1
    }
    {
      name: PWC_PCS_6_PHY_STATUS
      module_name: PWC_PCS_6
      type: interrupt
      intr_type: IntrType.Event
      default_val: false
      incoming: true
      width: 1
    }
    {
      name: PWC_PCS_7_ALL_PORTS_STATUS
      module_name: PWC_PCS_7
      type: interrupt
      intr_type: IntrType.Event
      default_val: false
      incoming: true
      width: 1
    }
    {
      name: PWC_PCS_7_LINK_BRINGUP_0
      module_name: PWC_PCS_7
      type: interrupt
      intr_type: IntrType.Event
      default_val: false
      incoming: true
      width: 1
    }
    {
      name: PWC_PCS_7_LINK_BRINGUP_1
      module_name: PWC_PCS_7
      type: interrupt
      intr_type: IntrType.Event
      default_val: false
      incoming: true
      width: 1
    }
    {
      name: PWC_PCS_7_LINK_BRINGUP_2
      module_name: PWC_PCS_7
      type: interrupt
      intr_type: IntrType.Event
      default_val: false
      incoming: true
      width: 1
    }
    {
      name: PWC_PCS_7_LINK_BRINGUP_3
      module_name: PWC_PCS_7
      type: interrupt
      intr_type: IntrType.Event
      default_val: false
      incoming: true
      width: 1
    }
    {
      name: PWC_PCS_7_MSG_CTRL
      module_name: PWC_PCS_7
      type: interrupt
      intr_type: IntrType.Event
      default_val: false
      incoming: true
      width: 1
    }
    {
      name: PWC_PCS_7_PHY_STATUS
      module_name: PWC_PCS_7
      type: interrupt
      intr_type: IntrType.Event
      default_val: false
      incoming: true
      width: 1
    }
    {
      name: PWC_HDR_IPI_FROM_PWC_0
      module_name: PWC_HDR
      type: interrupt
      intr_type: IntrType.Event
      default_val: false
      incoming: true
      width: 1
    }
    {
      name: PWC_HDR_IPI_FROM_PWC_1
      module_name: PWC_HDR
      type: interrupt
      intr_type: IntrType.Event
      default_val: false
      incoming: true
      width: 1
    }
    {
      name: PWC_HDR_IPI_FROM_PWC_2
      module_name: PWC_HDR
      type: interrupt
      intr_type: IntrType.Event
      default_val: false
      incoming: true
      width: 1
    }
    {
      name: PWC_HDR_IPI_FROM_ROT
      module_name: PWC_HDR
      type: interrupt
      intr_type: IntrType.Event
      default_val: false
      incoming: true
      width: 1
    }
    {
      name: PWC_HDR_IPI_FROM_MIO
      module_name: PWC_HDR
      type: interrupt
      intr_type: IntrType.Event
      default_val: false
      incoming: true
      width: 1
    }
    {
      name: PWC_HDR_IPI_FROM_DUC
      module_name: PWC_HDR
      type: interrupt
      intr_type: IntrType.Event
      default_val: false
      incoming: true
      width: 1
    }
  ]
  alert_module: []
  outgoing_alert_module:
  {
    pwc:
    [
      gpio
      rv_timer
      aon_timer_aon
      soc_proxy
      sram_ctrl_ret_aon
      rv_dm
      rv_plic
      sram_ctrl_main
      sram_ctrl_mbox
      dma
      mbx0
      mbx1
      mbx2
      mbx3
      mbx4
      mbx5
      rv_core_ibex
    ]
  }
  alert: []
  outgoing_alert:
  {
    pwc:
    [
      {
        name: gpio_fatal_fault
        width: 1
        type: alert
        async: "1"
        module_name: gpio
        lpg_name: clk_ext_io_div4_i_ext_rst_io_div4_0
        lpg_idx: 0
      }
      {
        name: rv_timer_fatal_fault
        width: 1
        type: alert
        async: "1"
        module_name: rv_timer
        lpg_name: clk_ext_io_div4_i_ext_rst_io_div4_0
        lpg_idx: 0
      }
      {
        name: aon_timer_aon_fatal_fault
        width: 1
        type: alert
        async: "1"
        module_name: aon_timer_aon
        lpg_name: clk_ext_io_div4_i_ext_rst_io_div4_0
        lpg_idx: 0
      }
      {
        name: soc_proxy_fatal_alert_intg
        width: 1
        type: alert
        async: "1"
        module_name: soc_proxy
        lpg_name: clk_ext_main_i_ext_rst_main_0
        lpg_idx: 1
      }
      {
        name: sram_ctrl_ret_aon_fatal_error
        width: 1
        type: alert
        async: "1"
        module_name: sram_ctrl_ret_aon
        lpg_name: clk_ext_io_div4_i_ext_rst_io_div4_0
        lpg_idx: 0
      }
      {
        name: rv_dm_fatal_fault
        width: 1
        type: alert
        async: "1"
        module_name: rv_dm
        lpg_name: clk_ext_main_i_ext_rst_main_0
        lpg_idx: 1
      }
      {
        name: rv_plic_fatal_fault
        width: 1
        type: alert
        async: "1"
        module_name: rv_plic
        lpg_name: clk_ext_main_i_ext_rst_main_0
        lpg_idx: 1
      }
      {
        name: sram_ctrl_main_fatal_error
        width: 1
        type: alert
        async: "1"
        module_name: sram_ctrl_main
        lpg_name: clk_ext_main_i_ext_rst_main_0
        lpg_idx: 1
      }
      {
        name: sram_ctrl_mbox_fatal_error
        width: 1
        type: alert
        async: "1"
        module_name: sram_ctrl_mbox
        lpg_name: clk_ext_main_i_ext_rst_main_0
        lpg_idx: 1
      }
      {
        name: dma_fatal_fault
        width: 1
        type: alert
        async: "1"
        module_name: dma
        lpg_name: clk_ext_main_i_ext_rst_main_0
        lpg_idx: 1
      }
      {
        name: mbx0_fatal_fault
        width: 1
        type: alert
        async: "1"
        module_name: mbx0
        lpg_name: clk_ext_main_i_ext_rst_main_0
        lpg_idx: 1
      }
      {
        name: mbx0_recov_fault
        width: 1
        type: alert
        async: "1"
        module_name: mbx0
        lpg_name: clk_ext_main_i_ext_rst_main_0
        lpg_idx: 1
      }
      {
        name: mbx1_fatal_fault
        width: 1
        type: alert
        async: "1"
        module_name: mbx1
        lpg_name: clk_ext_main_i_ext_rst_main_0
        lpg_idx: 1
      }
      {
        name: mbx1_recov_fault
        width: 1
        type: alert
        async: "1"
        module_name: mbx1
        lpg_name: clk_ext_main_i_ext_rst_main_0
        lpg_idx: 1
      }
      {
        name: mbx2_fatal_fault
        width: 1
        type: alert
        async: "1"
        module_name: mbx2
        lpg_name: clk_ext_main_i_ext_rst_main_0
        lpg_idx: 1
      }
      {
        name: mbx2_recov_fault
        width: 1
        type: alert
        async: "1"
        module_name: mbx2
        lpg_name: clk_ext_main_i_ext_rst_main_0
        lpg_idx: 1
      }
      {
        name: mbx3_fatal_fault
        width: 1
        type: alert
        async: "1"
        module_name: mbx3
        lpg_name: clk_ext_main_i_ext_rst_main_0
        lpg_idx: 1
      }
      {
        name: mbx3_recov_fault
        width: 1
        type: alert
        async: "1"
        module_name: mbx3
        lpg_name: clk_ext_main_i_ext_rst_main_0
        lpg_idx: 1
      }
      {
        name: mbx4_fatal_fault
        width: 1
        type: alert
        async: "1"
        module_name: mbx4
        lpg_name: clk_ext_main_i_ext_rst_main_0
        lpg_idx: 1
      }
      {
        name: mbx4_recov_fault
        width: 1
        type: alert
        async: "1"
        module_name: mbx4
        lpg_name: clk_ext_main_i_ext_rst_main_0
        lpg_idx: 1
      }
      {
        name: mbx5_fatal_fault
        width: 1
        type: alert
        async: "1"
        module_name: mbx5
        lpg_name: clk_ext_main_i_ext_rst_main_0
        lpg_idx: 1
      }
      {
        name: mbx5_recov_fault
        width: 1
        type: alert
        async: "1"
        module_name: mbx5
        lpg_name: clk_ext_main_i_ext_rst_main_0
        lpg_idx: 1
      }
      {
        name: rv_core_ibex_fatal_sw_err
        width: 1
        type: alert
        async: "1"
        module_name: rv_core_ibex
        lpg_name: clk_ext_main_i_ext_rst_main_0
        lpg_idx: 1
      }
      {
        name: rv_core_ibex_recov_sw_err
        width: 1
        type: alert
        async: "1"
        module_name: rv_core_ibex
        lpg_name: clk_ext_main_i_ext_rst_main_0
        lpg_idx: 1
      }
      {
        name: rv_core_ibex_fatal_hw_err
        width: 1
        type: alert
        async: "1"
        module_name: rv_core_ibex
        lpg_name: clk_ext_main_i_ext_rst_main_0
        lpg_idx: 1
      }
      {
        name: rv_core_ibex_recov_hw_err
        width: 1
        type: alert
        async: "1"
        module_name: rv_core_ibex
        lpg_name: clk_ext_main_i_ext_rst_main_0
        lpg_idx: 1
      }
    ]
  }
  exported_rsts: {}
  alert_lpgs: []
  outgoing_alert_lpgs:
  {
    pwc:
    [
      {
        name: clk_ext_io_div4_i_ext_rst_io_div4_0
        clock_group: null
        clock_connection: clk_ext_io_div4_i
        unmanaged_clock: true
        unmanaged_reset: true
        reset_connection:
        {
          name: ext_rst_io_div4
          domain: "0"
        }
      }
      {
        name: clk_ext_main_i_ext_rst_main_0
        clock_group: null
        clock_connection: clk_ext_main_i
        unmanaged_clock: true
        unmanaged_reset: true
        reset_connection:
        {
          name: ext_rst_main
          domain: "0"
        }
      }
    ]
  }
  inter_signal:
  {
    signals:
    [
      {
        name: strap_en
        desc: This signal is pulsed high by the power manager after reset in order to sample the HW straps.
        struct: logic
        type: uni
        act: rcv
        width: 1
        default: 1'b0
        inst_name: gpio
        index: -1
      }
      {
        name: sampled_straps
        desc: This vector contains the sampled strap values.
        struct: gpio_straps
        package: gpio_pkg
        type: uni
        act: req
        width: 1
        default: "'0"
        inst_name: gpio
        index: -1
      }
      {
        name: tl
        struct: tl
        package: tlul_pkg
        type: req_rsp
        act: rsp
        width: 1
        inst_name: gpio
        default: ""
        end_idx: -1
        top_signame: gpio_tl
        index: -1
      }
      {
        name: tl
        struct: tl
        package: tlul_pkg
        type: req_rsp
        act: rsp
        width: 1
        inst_name: rv_timer
        default: ""
        end_idx: -1
        top_signame: rv_timer_tl
        index: -1
      }
      {
        name: nmi_wdog_timer_bark
        struct: logic
        type: uni
        act: req
        width: 1
        default: 1'b0
        inst_name: aon_timer_aon
        package: ""
        end_idx: -1
        top_type: broadcast
        top_signame: aon_timer_aon_nmi_wdog_timer_bark
        index: -1
      }
      {
        name: wkup_req
        struct: logic
        type: uni
        act: req
        width: 1
        default: 1'b0
        inst_name: aon_timer_aon
        index: -1
      }
      {
        name: aon_timer_rst_req
        struct: logic
        type: uni
        act: req
        width: 1
        default: 1'b0
        inst_name: aon_timer_aon
        index: -1
      }
      {
        name: lc_escalate_en
        struct: lc_tx
        package: lc_ctrl_pkg
        type: uni
        act: rcv
        width: 1
        default: lc_ctrl_pkg::Off
        inst_name: aon_timer_aon
        top_signame: soc_proxy_lc_escalate_en
        index: -1
      }
      {
        name: sleep_mode
        struct: logic
        type: uni
        act: rcv
        width: 1
        inst_name: aon_timer_aon
        index: -1
      }
      {
        name: tl
        struct: tl
        package: tlul_pkg
        type: req_rsp
        act: rsp
        width: 1
        inst_name: aon_timer_aon
        default: ""
        end_idx: -1
        top_signame: aon_timer_aon_tl
        index: -1
      }
      {
        name: lc_escalate_en
        desc:
          '''
          Escalation enable signal coming from life cycle controller, used for invalidating
          the latched lc_hw_debug_en state inside the strap sampling logic.
          '''
        struct: lc_tx
        package: lc_ctrl_pkg
        type: uni
        act: req
        width: 1
        default: lc_ctrl_pkg::Off
        inst_name: soc_proxy
        end_idx: -1
        top_type: broadcast
        top_signame: soc_proxy_lc_escalate_en
        index: -1
      }
      {
        name: lc_escalate_en_ext
        desc:
          '''
          Escalation enable signal coming from life cycle controller, used for invalidating
          the latched lc_hw_debug_en state inside the strap sampling logic.
          '''
        struct: lc_tx
        package: lc_ctrl_pkg
        type: uni
        act: rcv
        width: 1
        default: lc_ctrl_pkg::Off
        inst_name: soc_proxy
        external: true
        top_signame: lc_escalate_en_ext
        conn_type: false
        index: -1
      }
      {
        name: lc_hw_debug_en
        desc:
          '''
          Multibit life cycle hardware debug enable signal coming from life cycle controller,
          asserted when the hardware debug mechanisms are enabled in the system.
          '''
        struct: lc_tx
        package: lc_ctrl_pkg
        type: uni
        act: req
        width: 1
        default: lc_ctrl_pkg::Off
        inst_name: soc_proxy
        end_idx: -1
        top_type: broadcast
        top_signame: soc_proxy_lc_hw_debug_en
        index: -1
      }
      {
        name: lc_hw_debug_en_ext
        desc:
          '''
          Multibit life cycle hardware debug enable signal coming from life cycle controller,
          asserted when the hardware debug mechanisms are enabled in the system.
          '''
        struct: lc_tx
        package: lc_ctrl_pkg
        type: uni
        act: rcv
        width: 1
        default: lc_ctrl_pkg::Off
        inst_name: soc_proxy
        external: true
        top_signame: lc_hw_debug_en_ext
        conn_type: false
        index: -1
      }
      {
        name: ctn_tl_h2d
        desc: TL-UL host port for egress into CTN (request part), synchronous
        struct: tl_h2d
        package: tlul_pkg
        type: uni
        act: req
        width: 1
        inst_name: soc_proxy
        default: ""
        external: true
        top_signame: ctn_tl_h2d
        conn_type: false
        index: -1
      }
      {
        name: ctn_tl_d2h
        desc: TL-UL host port for egress into CTN (response part), synchronous
        struct: tl_d2h
        package: tlul_pkg
        type: uni
        act: rcv
        width: 1
        inst_name: soc_proxy
        default: ""
        external: true
        top_signame: ctn_tl_d2h
        conn_type: false
        index: -1
      }
      {
        name: soc_lsio_trigger
        desc: LSIO trigger signal from SoC, synchronous
        struct: logic
        type: uni
        act: rcv
        width: 8
        inst_name: soc_proxy
        default: ""
        package: ""
        external: true
        top_signame: soc_lsio_trigger
        conn_type: false
        index: -1
      }
      {
        name: dma_lsio_trigger
        desc: Collated synchronous LSIO trigger signals for DMA
        struct: lsio_trigger
        package: dma_pkg
        type: uni
        act: req
        width: 1
        inst_name: soc_proxy
        default: ""
        top_signame: dma_lsio_trigger
        index: -1
      }
      {
        name: soc_intr_async
        desc: Interrupt request from SoC, asynchronous, level-encoded
        struct: logic
        type: uni
        act: rcv
        width: 32
        inst_name: soc_proxy
        index: -1
      }
      {
        name: mubi8_true
        struct: mubi8
        package: prim_mubi_pkg
        type: uni
        act: req
        width: 1
        default: prim_mubi_pkg::MuBi8False
        inst_name: soc_proxy
        top_signame: sram_ctrl_main_otp_en_sram_ifetch
        index: -1
      }
      {
        name: core_tl
        struct: tl
        package: tlul_pkg
        type: req_rsp
        act: rsp
        width: 1
        inst_name: soc_proxy
        default: ""
        end_idx: -1
        top_signame: soc_proxy_core_tl
        index: -1
      }
      {
        name: ctn_tl
        struct: tl
        package: tlul_pkg
        type: req_rsp
        act: rsp
        width: 1
        inst_name: soc_proxy
        default: ""
        end_idx: -1
        top_signame: soc_proxy_ctn_tl
        index: -1
      }
      {
        name: sram_otp_key
        struct: sram_otp_key
        package: otp_ctrl_pkg
        type: req_rsp
        act: req
        width: 1
        inst_name: sram_ctrl_ret_aon
        index: -1
      }
      {
        name: cfg
        struct: ram_1p_cfg
        package: prim_ram_1p_pkg
        type: uni
        act: rcv
        width:
        {
          name: NumRamInst
          desc: Number of internal RAM instances. Must be the same as ceil(MemSizeRam / InstSize) .
          param_type: int
          unpacked_dimensions: null
          default: 1
          local: false
          expose: true
          name_top: SramCtrlRetAonNumRamInst
        }
        default: "'0"
        inst_name: sram_ctrl_ret_aon
        external: true
        top_signame: sram_ctrl_ret_aon_ram_1p_cfg
        conn_type: false
        index: -1
      }
      {
        name: cfg_rsp
        struct: ram_1p_cfg_rsp
        package: prim_ram_1p_pkg
        type: uni
        act: req
        width:
        {
          name: NumRamInst
          desc: Number of internal RAM instances. Must be the same as ceil(MemSizeRam / InstSize) .
          param_type: int
          unpacked_dimensions: null
          default: 1
          local: false
          expose: true
          name_top: SramCtrlRetAonNumRamInst
        }
        default: "'0"
        inst_name: sram_ctrl_ret_aon
        external: true
        top_signame: sram_ctrl_ret_aon_ram_1p_cfg_rsp
        conn_type: false
        index: -1
      }
      {
        name: lc_escalate_en
        struct: lc_tx
        package: lc_ctrl_pkg
        type: uni
        act: rcv
        width: 1
        default: lc_ctrl_pkg::Off
        inst_name: sram_ctrl_ret_aon
        top_signame: soc_proxy_lc_escalate_en
        index: -1
      }
      {
        name: lc_hw_debug_en
        struct: lc_tx
        package: lc_ctrl_pkg
        type: uni
        act: rcv
        width: 1
        default: lc_ctrl_pkg::Off
        inst_name: sram_ctrl_ret_aon
        top_signame: soc_proxy_lc_hw_debug_en
        index: -1
      }
      {
        name: otp_en_sram_ifetch
        struct: mubi8
        package: prim_mubi_pkg
        type: uni
        act: rcv
        width: 1
        default: prim_mubi_pkg::MuBi8False
        inst_name: sram_ctrl_ret_aon
        index: -1
      }
      {
        name: sram_error_record_uncor_err
        desc: SRAM Error injection reporting
        struct: logic
        type: uni
        act: req
        width: 1
        inst_name: sram_ctrl_ret_aon
        index: -1
      }
      {
        name: sram_error_record_corr_err
        desc: SRAM Error injection reporting
        struct: logic
        type: uni
        act: req
        width: 1
        inst_name: sram_ctrl_ret_aon
        index: -1
      }
      {
        name: sram_error_record_err_addr
        desc: SRAM Error injection reporting
        struct: logic [top_pkg::TL_AW-1:0]
        type: uni
        act: req
        width: 1
        inst_name: sram_ctrl_ret_aon
        index: -1
      }
      {
        name: regs_tl
        struct: tl
        package: tlul_pkg
        type: req_rsp
        act: rsp
        width: 1
        inst_name: sram_ctrl_ret_aon
        default: ""
        end_idx: -1
        top_signame: sram_ctrl_ret_aon_regs_tl
        index: -1
      }
      {
        name: ram_tl
        struct: tl
        package: tlul_pkg
        type: req_rsp
        act: rsp
        width: 1
        inst_name: sram_ctrl_ret_aon
        default: ""
        end_idx: -1
        top_signame: sram_ctrl_ret_aon_ram_tl
        index: -1
      }
      {
        name: next_dm_addr
        desc:
          '''
          32bit word address of the next debug module.
          Set to 0x0 if this is the last debug module in the chain.
          '''
        struct: next_dm_addr
        package: rv_dm_pkg
        type: uni
        act: rcv
        width: 1
        default: "'0"
        inst_name: rv_dm
        external: true
        top_signame: rv_dm_next_dm_addr
        conn_type: false
        index: -1
      }
      {
        name: jtag
        desc: JTAG signals for the RISC-V TAP.
        struct: jtag
        package: jtag_pkg
        type: req_rsp
        act: rsp
        width: 1
        inst_name: rv_dm
        index: -1
      }
      {
        name: lc_hw_debug_en
        desc:
          '''
          Multibit life cycle hardware debug enable signal coming from life cycle controller,
          asserted when the hardware debug mechanisms are enabled in the system.
          '''
        struct: lc_tx
        package: lc_ctrl_pkg
        type: uni
        act: rcv
        width: 1
        default: lc_ctrl_pkg::Off
        inst_name: rv_dm
        top_signame: soc_proxy_lc_hw_debug_en
        index: -1
      }
      {
        name: lc_dft_en
        desc:
          '''
          Multibit life cycle hardware debug enable signal coming from life cycle controller,
          asserted when the DFT mechanisms are enabled in the system.
          '''
        struct: lc_tx
        package: lc_ctrl_pkg
        type: uni
        act: rcv
        width: 1
        default: lc_ctrl_pkg::Off
        inst_name: rv_dm
        index: -1
      }
      {
        name: pinmux_hw_debug_en
        desc:
          '''
          Multibit life cycle hardware debug enable signal coming from pinmux.
          This is a latched version of the lc_hw_debug_en signal and is only used to
          gate the JTAG / TAP side of the RV_DM. It is used to keep a debug session live
          while the rest of the system undergoes an NDM reset.
          '''
        struct: lc_tx
        package: lc_ctrl_pkg
        type: uni
        act: rcv
        width: 1
        default: lc_ctrl_pkg::Off
        inst_name: rv_dm
        index: -1
      }
      {
        name: otp_dis_rv_dm_late_debug
        struct: mubi8
        package: prim_mubi_pkg
        type: uni
        act: rcv
        width: 1
        default: prim_mubi_pkg::MuBi8False
        inst_name: rv_dm
        index: -1
      }
      {
        name: unavailable
        desc:
          '''
          This signal indicates to the debug module that the main processor is not available
          for debug (e.g. due to a low-power state).
          '''
        struct: logic
        type: uni
        act: rcv
        width: 1
        default: 1'b0
        inst_name: rv_dm
        index: -1
      }
      {
        name: ndmreset_req
        desc: Non-debug module reset request going to the system reset infrastructure.
        struct: logic
        type: uni
        act: req
        width: 1
        inst_name: rv_dm
        index: -1
      }
      {
        name: dmactive
        desc:
          '''
          This signal indicates whether the debug module is active and can be used to prevent
          power down of the core and bus-attached peripherals.
          '''
        struct: logic
        type: uni
        act: req
        width: 1
        inst_name: rv_dm
        index: -1
      }
      {
        name: debug_req
        desc: This is the debug request interrupt going to the main processor.
        struct: logic [rv_dm_reg_pkg::NrHarts-1:0]
        type: uni
        act: req
        width: 1
        inst_name: rv_dm
        default: ""
        package: ""
        end_idx: -1
        top_type: broadcast
        top_signame: rv_dm_debug_req
        index: -1
      }
      {
        name: lc_escalate_en
        desc:
          '''
          Escalation enable signal coming from life cycle controller, used for invalidating
          the latched lc_hw_debug_en state inside the strap sampling logic.
          '''
        struct: lc_tx
        package: lc_ctrl_pkg
        type: uni
        act: rcv
        width: 1
        default: lc_ctrl_pkg::Off
        inst_name: rv_dm
        top_signame: soc_proxy_lc_escalate_en
        index: -1
      }
      {
        name: lc_check_byp_en
        desc:
          '''
          Check bypass enable signal coming from life cycle controller, used for invalidating
          the latched lc_hw_debug_en state inside the strap sampling logic. This signal is asserted
          whenever the life cycle controller performs a life cycle transition. Its main use is
          to skip any background checks inside the life cycle partition of the OTP controller while
          a life cycle transition is in progress.
          '''
        struct: lc_tx
        package: lc_ctrl_pkg
        type: uni
        act: rcv
        width: 1
        default: lc_ctrl_pkg::Off
        inst_name: rv_dm
        external: true
        top_signame: lc_check_byp_en
        conn_type: false
        index: -1
      }
      {
        name: strap_en
        desc: This signal is pulsed high by the power manager after reset in order to sample the HW straps.
        struct: logic
        type: uni
        act: rcv
        width: 1
        default: 1'b0
        inst_name: rv_dm
        index: -1
      }
      {
        name: strap_en_override
        desc:
          '''
          This signal transitions from 0 -> 1 by the lc_ctrl manager after volatile RAW_UNLOCK in order to re-sample the HW straps.
          The signal must stay at 1 until reset.
          Note that this is only used in test chips when SecVolatileRawUnlockEn = 1.
          Otherwise this signal is unused.
          '''
        struct: logic
        type: uni
        act: rcv
        width: 1
        default: 1'b0
        inst_name: rv_dm
        index: -1
      }
      {
        name: sba_tl_h
        struct: tl
        package: tlul_pkg
        type: req_rsp
        act: req
        width: 1
        inst_name: rv_dm
        default: ""
        top_signame: pwc_main_tl_rv_dm__sba
        index: -1
      }
      {
        name: regs_tl_d
        struct: tl
        package: tlul_pkg
        type: req_rsp
        act: rsp
        width: 1
        inst_name: rv_dm
        default: ""
        end_idx: -1
        top_signame: rv_dm_regs_tl_d
        index: -1
      }
      {
        name: mem_tl_d
        struct: tl
        package: tlul_pkg
        type: req_rsp
        act: rsp
        width: 1
        inst_name: rv_dm
        default: ""
        end_idx: -1
        top_signame: rv_dm_mem_tl_d
        index: -1
      }
      {
        name: dbg_tl_d
        struct: tl
        package: tlul_pkg
        type: req_rsp
        act: rsp
        width: 1
        inst_name: rv_dm
        default: ""
        external: true
        top_signame: rv_dm_dbg
        conn_type: false
        index: -1
      }
      {
        name: irq
        struct: logic
        type: uni
        act: req
        width: 1
        inst_name: rv_plic
        default: ""
        package: ""
        end_idx: -1
        top_type: broadcast
        top_signame: rv_plic_irq
        index: -1
      }
      {
        name: irq_id
        struct: logic
        type: uni
        act: req
        width: 1
        inst_name: rv_plic
        index: -1
      }
      {
        name: msip
        struct: logic
        type: uni
        act: req
        width: 1
        inst_name: rv_plic
        default: ""
        package: ""
        end_idx: -1
        top_type: broadcast
        top_signame: rv_plic_msip
        index: -1
      }
      {
        name: tl
        struct: tl
        package: tlul_pkg
        type: req_rsp
        act: rsp
        width: 1
        inst_name: rv_plic
        default: ""
        end_idx: -1
        top_signame: rv_plic_tl
        index: -1
      }
      {
        name: sram_otp_key
        struct: sram_otp_key
        package: otp_ctrl_pkg
        type: req_rsp
        act: req
        width: 1
        inst_name: sram_ctrl_main
        index: -1
      }
      {
        name: cfg
        struct: ram_1p_cfg
        package: prim_ram_1p_pkg
        type: uni
        act: rcv
        width:
        {
          name: NumRamInst
          desc: Number of internal RAM instances. Must be the same as ceil(MemSizeRam / InstSize) .
          param_type: int
          unpacked_dimensions: null
          default: 1
          local: false
          expose: true
          name_top: SramCtrlMainNumRamInst
        }
        default: "'0"
        inst_name: sram_ctrl_main
        external: true
        top_signame: sram_ctrl_main_ram_1p_cfg
        conn_type: false
        index: -1
      }
      {
        name: cfg_rsp
        struct: ram_1p_cfg_rsp
        package: prim_ram_1p_pkg
        type: uni
        act: req
        width:
        {
          name: NumRamInst
          desc: Number of internal RAM instances. Must be the same as ceil(MemSizeRam / InstSize) .
          param_type: int
          unpacked_dimensions: null
          default: 1
          local: false
          expose: true
          name_top: SramCtrlMainNumRamInst
        }
        default: "'0"
        inst_name: sram_ctrl_main
        external: true
        top_signame: sram_ctrl_main_ram_1p_cfg_rsp
        conn_type: false
        index: -1
      }
      {
        name: lc_escalate_en
        struct: lc_tx
        package: lc_ctrl_pkg
        type: uni
        act: rcv
        width: 1
        default: lc_ctrl_pkg::Off
        inst_name: sram_ctrl_main
        top_signame: soc_proxy_lc_escalate_en
        index: -1
      }
      {
        name: lc_hw_debug_en
        struct: lc_tx
        package: lc_ctrl_pkg
        type: uni
        act: rcv
        width: 1
        default: lc_ctrl_pkg::Off
        inst_name: sram_ctrl_main
        top_signame: soc_proxy_lc_hw_debug_en
        index: -1
      }
      {
        name: otp_en_sram_ifetch
        struct: mubi8
        package: prim_mubi_pkg
        type: uni
        act: rcv
        width: 1
        default: prim_mubi_pkg::MuBi8False
        inst_name: sram_ctrl_main
        end_idx: -1
        top_type: broadcast
        top_signame: sram_ctrl_main_otp_en_sram_ifetch
        index: -1
      }
      {
        name: sram_error_record_uncor_err
        desc: SRAM Error injection reporting
        struct: logic
        type: uni
        act: req
        width: 1
        inst_name: sram_ctrl_main
        index: -1
      }
      {
        name: sram_error_record_corr_err
        desc: SRAM Error injection reporting
        struct: logic
        type: uni
        act: req
        width: 1
        inst_name: sram_ctrl_main
        index: -1
      }
      {
        name: sram_error_record_err_addr
        desc: SRAM Error injection reporting
        struct: logic [top_pkg::TL_AW-1:0]
        type: uni
        act: req
        width: 1
        inst_name: sram_ctrl_main
        index: -1
      }
      {
        name: regs_tl
        struct: tl
        package: tlul_pkg
        type: req_rsp
        act: rsp
        width: 1
        inst_name: sram_ctrl_main
        default: ""
        end_idx: -1
        top_signame: sram_ctrl_main_regs_tl
        index: -1
      }
      {
        name: ram_tl
        struct: tl
        package: tlul_pkg
        type: req_rsp
        act: rsp
        width: 1
        inst_name: sram_ctrl_main
        default: ""
        end_idx: -1
        top_signame: sram_ctrl_main_ram_tl
        index: -1
      }
      {
        name: sram_otp_key
        struct: sram_otp_key
        package: otp_ctrl_pkg
        type: req_rsp
        act: req
        width: 1
        inst_name: sram_ctrl_mbox
        index: -1
      }
      {
        name: cfg
        struct: ram_1p_cfg
        package: prim_ram_1p_pkg
        type: uni
        act: rcv
        width:
        {
          name: NumRamInst
          desc: Number of internal RAM instances. Must be the same as ceil(MemSizeRam / InstSize) .
          param_type: int
          unpacked_dimensions: null
          default: 1
          local: false
          expose: true
          name_top: SramCtrlMboxNumRamInst
        }
        default: "'0"
        inst_name: sram_ctrl_mbox
        external: true
        top_signame: sram_ctrl_mbox_ram_1p_cfg
        conn_type: false
        index: -1
      }
      {
        name: cfg_rsp
        struct: ram_1p_cfg_rsp
        package: prim_ram_1p_pkg
        type: uni
        act: req
        width:
        {
          name: NumRamInst
          desc: Number of internal RAM instances. Must be the same as ceil(MemSizeRam / InstSize) .
          param_type: int
          unpacked_dimensions: null
          default: 1
          local: false
          expose: true
          name_top: SramCtrlMboxNumRamInst
        }
        default: "'0"
        inst_name: sram_ctrl_mbox
        external: true
        top_signame: sram_ctrl_mbox_ram_1p_cfg_rsp
        conn_type: false
        index: -1
      }
      {
        name: lc_escalate_en
        struct: lc_tx
        package: lc_ctrl_pkg
        type: uni
        act: rcv
        width: 1
        default: lc_ctrl_pkg::Off
        inst_name: sram_ctrl_mbox
        top_signame: soc_proxy_lc_escalate_en
        index: -1
      }
      {
        name: lc_hw_debug_en
        struct: lc_tx
        package: lc_ctrl_pkg
        type: uni
        act: rcv
        width: 1
        default: lc_ctrl_pkg::Off
        inst_name: sram_ctrl_mbox
        top_signame: soc_proxy_lc_hw_debug_en
        index: -1
      }
      {
        name: otp_en_sram_ifetch
        struct: mubi8
        package: prim_mubi_pkg
        type: uni
        act: rcv
        width: 1
        default: prim_mubi_pkg::MuBi8False
        inst_name: sram_ctrl_mbox
        index: -1
      }
      {
        name: sram_error_record_uncor_err
        desc: SRAM Error injection reporting
        struct: logic
        type: uni
        act: req
        width: 1
        inst_name: sram_ctrl_mbox
        index: -1
      }
      {
        name: sram_error_record_corr_err
        desc: SRAM Error injection reporting
        struct: logic
        type: uni
        act: req
        width: 1
        inst_name: sram_ctrl_mbox
        index: -1
      }
      {
        name: sram_error_record_err_addr
        desc: SRAM Error injection reporting
        struct: logic [top_pkg::TL_AW-1:0]
        type: uni
        act: req
        width: 1
        inst_name: sram_ctrl_mbox
        index: -1
      }
      {
        name: regs_tl
        struct: tl
        package: tlul_pkg
        type: req_rsp
        act: rsp
        width: 1
        inst_name: sram_ctrl_mbox
        default: ""
        end_idx: -1
        top_signame: sram_ctrl_mbox_regs_tl
        index: -1
      }
      {
        name: ram_tl
        struct: tl
        package: tlul_pkg
        type: req_rsp
        act: rsp
        width: 1
        inst_name: sram_ctrl_mbox
        default: ""
        end_idx: -1
        top_signame: sram_ctrl_mbox_ram_tl
        index: -1
      }
      {
        name: lsio_trigger
        struct: lsio_trigger
        package: dma_pkg
        type: uni
        act: rcv
        width: 1
        inst_name: dma
        default: ""
        end_idx: -1
        top_type: broadcast
        top_signame: dma_lsio_trigger
        index: -1
      }
      {
        name: sys
        struct: sys
        package: dma_pkg
        type: req_rsp
        act: req
        width: 1
        inst_name: dma
        default: ""
        external: true
        top_signame: dma_sys
        conn_type: false
        index: -1
      }
      {
        name: ctn_tl_h2d
        desc: TL-UL host port for egress into CTN (request part), synchronous
        struct: tl_h2d
        package: tlul_pkg
        type: uni
        act: req
        width: 1
        inst_name: dma
        default: ""
        external: true
        top_signame: dma_ctn_tl_h2d
        conn_type: false
        index: -1
      }
      {
        name: ctn_tl_d2h
        desc: TL-UL host port for egress into CTN (response part), synchronous
        struct: tl_d2h
        package: tlul_pkg
        type: uni
        act: rcv
        width: 1
        inst_name: dma
        default: ""
        external: true
        top_signame: dma_ctn_tl_d2h
        conn_type: false
        index: -1
      }
      {
        name: host_tl_h
        struct: tl
        package: tlul_pkg
        type: req_rsp
        act: req
        width: 1
        inst_name: dma
        default: ""
        top_signame: pwc_main_tl_dma__host
        index: -1
      }
      {
        name: tl_d
        struct: tl
        package: tlul_pkg
        type: req_rsp
        act: rsp
        width: 1
        inst_name: dma
        default: ""
        end_idx: -1
        top_signame: dma_tl_d
        index: -1
      }
      {
        name: doe_intr_support
        struct: logic
        type: uni
        act: req
        width: 1
        default: 1'b0
        inst_name: mbx0
        index: -1
      }
      {
        name: doe_intr_en
        struct: logic
        type: uni
        act: req
        width: 1
        default: 1'b0
        inst_name: mbx0
        index: -1
      }
      {
        name: doe_intr
        struct: logic
        type: uni
        act: req
        width: 1
        default: 1'b0
        inst_name: mbx0
        index: -1
      }
      {
        name: doe_async_msg_support
        struct: logic
        type: uni
        act: req
        width: 1
        default: 1'b0
        inst_name: mbx0
        index: -1
      }
      {
        name: sram_tl_h
        struct: tl
        package: tlul_pkg
        type: req_rsp
        act: req
        width: 1
        inst_name: mbx0
        default: ""
        top_signame: pwc_main_tl_mbx0__sram
        index: -1
      }
      {
        name: core_tl_d
        struct: tl
        package: tlul_pkg
        type: req_rsp
        act: rsp
        width: 1
        inst_name: mbx0
        default: ""
        end_idx: -1
        top_signame: mbx0_core_tl_d
        index: -1
      }
      {
        name: soc_tl_d
        struct: tl
        package: tlul_pkg
        type: req_rsp
        act: rsp
        width: 1
        inst_name: mbx0
        default: ""
        end_idx: -1
        top_signame: mbx0_soc_tl_d
        index: -1
      }
      {
        name: doe_intr_support
        struct: logic
        type: uni
        act: req
        width: 1
        default: 1'b0
        inst_name: mbx1
        index: -1
      }
      {
        name: doe_intr_en
        struct: logic
        type: uni
        act: req
        width: 1
        default: 1'b0
        inst_name: mbx1
        index: -1
      }
      {
        name: doe_intr
        struct: logic
        type: uni
        act: req
        width: 1
        default: 1'b0
        inst_name: mbx1
        index: -1
      }
      {
        name: doe_async_msg_support
        struct: logic
        type: uni
        act: req
        width: 1
        default: 1'b0
        inst_name: mbx1
        index: -1
      }
      {
        name: sram_tl_h
        struct: tl
        package: tlul_pkg
        type: req_rsp
        act: req
        width: 1
        inst_name: mbx1
        default: ""
        top_signame: pwc_main_tl_mbx1__sram
        index: -1
      }
      {
        name: core_tl_d
        struct: tl
        package: tlul_pkg
        type: req_rsp
        act: rsp
        width: 1
        inst_name: mbx1
        default: ""
        end_idx: -1
        top_signame: mbx1_core_tl_d
        index: -1
      }
      {
        name: soc_tl_d
        struct: tl
        package: tlul_pkg
        type: req_rsp
        act: rsp
        width: 1
        inst_name: mbx1
        default: ""
        end_idx: -1
        top_signame: mbx1_soc_tl_d
        index: -1
      }
      {
        name: doe_intr_support
        struct: logic
        type: uni
        act: req
        width: 1
        default: 1'b0
        inst_name: mbx2
        index: -1
      }
      {
        name: doe_intr_en
        struct: logic
        type: uni
        act: req
        width: 1
        default: 1'b0
        inst_name: mbx2
        index: -1
      }
      {
        name: doe_intr
        struct: logic
        type: uni
        act: req
        width: 1
        default: 1'b0
        inst_name: mbx2
        index: -1
      }
      {
        name: doe_async_msg_support
        struct: logic
        type: uni
        act: req
        width: 1
        default: 1'b0
        inst_name: mbx2
        index: -1
      }
      {
        name: sram_tl_h
        struct: tl
        package: tlul_pkg
        type: req_rsp
        act: req
        width: 1
        inst_name: mbx2
        default: ""
        top_signame: pwc_main_tl_mbx2__sram
        index: -1
      }
      {
        name: core_tl_d
        struct: tl
        package: tlul_pkg
        type: req_rsp
        act: rsp
        width: 1
        inst_name: mbx2
        default: ""
        end_idx: -1
        top_signame: mbx2_core_tl_d
        index: -1
      }
      {
        name: soc_tl_d
        struct: tl
        package: tlul_pkg
        type: req_rsp
        act: rsp
        width: 1
        inst_name: mbx2
        default: ""
        end_idx: -1
        top_signame: mbx2_soc_tl_d
        index: -1
      }
      {
        name: doe_intr_support
        struct: logic
        type: uni
        act: req
        width: 1
        default: 1'b0
        inst_name: mbx3
        index: -1
      }
      {
        name: doe_intr_en
        struct: logic
        type: uni
        act: req
        width: 1
        default: 1'b0
        inst_name: mbx3
        index: -1
      }
      {
        name: doe_intr
        struct: logic
        type: uni
        act: req
        width: 1
        default: 1'b0
        inst_name: mbx3
        index: -1
      }
      {
        name: doe_async_msg_support
        struct: logic
        type: uni
        act: req
        width: 1
        default: 1'b0
        inst_name: mbx3
        index: -1
      }
      {
        name: sram_tl_h
        struct: tl
        package: tlul_pkg
        type: req_rsp
        act: req
        width: 1
        inst_name: mbx3
        default: ""
        top_signame: pwc_main_tl_mbx3__sram
        index: -1
      }
      {
        name: core_tl_d
        struct: tl
        package: tlul_pkg
        type: req_rsp
        act: rsp
        width: 1
        inst_name: mbx3
        default: ""
        end_idx: -1
        top_signame: mbx3_core_tl_d
        index: -1
      }
      {
        name: soc_tl_d
        struct: tl
        package: tlul_pkg
        type: req_rsp
        act: rsp
        width: 1
        inst_name: mbx3
        default: ""
        end_idx: -1
        top_signame: mbx3_soc_tl_d
        index: -1
      }
      {
        name: doe_intr_support
        struct: logic
        type: uni
        act: req
        width: 1
        default: 1'b0
        inst_name: mbx4
        index: -1
      }
      {
        name: doe_intr_en
        struct: logic
        type: uni
        act: req
        width: 1
        default: 1'b0
        inst_name: mbx4
        index: -1
      }
      {
        name: doe_intr
        struct: logic
        type: uni
        act: req
        width: 1
        default: 1'b0
        inst_name: mbx4
        index: -1
      }
      {
        name: doe_async_msg_support
        struct: logic
        type: uni
        act: req
        width: 1
        default: 1'b0
        inst_name: mbx4
        index: -1
      }
      {
        name: sram_tl_h
        struct: tl
        package: tlul_pkg
        type: req_rsp
        act: req
        width: 1
        inst_name: mbx4
        default: ""
        top_signame: pwc_main_tl_mbx4__sram
        index: -1
      }
      {
        name: core_tl_d
        struct: tl
        package: tlul_pkg
        type: req_rsp
        act: rsp
        width: 1
        inst_name: mbx4
        default: ""
        end_idx: -1
        top_signame: mbx4_core_tl_d
        index: -1
      }
      {
        name: soc_tl_d
        struct: tl
        package: tlul_pkg
        type: req_rsp
        act: rsp
        width: 1
        inst_name: mbx4
        default: ""
        end_idx: -1
        top_signame: mbx4_soc_tl_d
        index: -1
      }
      {
        name: doe_intr_support
        struct: logic
        type: uni
        act: req
        width: 1
        default: 1'b0
        inst_name: mbx5
        index: -1
      }
      {
        name: doe_intr_en
        struct: logic
        type: uni
        act: req
        width: 1
        default: 1'b0
        inst_name: mbx5
        index: -1
      }
      {
        name: doe_intr
        struct: logic
        type: uni
        act: req
        width: 1
        default: 1'b0
        inst_name: mbx5
        index: -1
      }
      {
        name: doe_async_msg_support
        struct: logic
        type: uni
        act: req
        width: 1
        default: 1'b0
        inst_name: mbx5
        index: -1
      }
      {
        name: sram_tl_h
        struct: tl
        package: tlul_pkg
        type: req_rsp
        act: req
        width: 1
        inst_name: mbx5
        default: ""
        top_signame: pwc_main_tl_mbx5__sram
        index: -1
      }
      {
        name: core_tl_d
        struct: tl
        package: tlul_pkg
        type: req_rsp
        act: rsp
        width: 1
        inst_name: mbx5
        default: ""
        end_idx: -1
        top_signame: mbx5_core_tl_d
        index: -1
      }
      {
        name: soc_tl_d
        struct: tl
        package: tlul_pkg
        type: req_rsp
        act: rsp
        width: 1
        inst_name: mbx5
        default: ""
        end_idx: -1
        top_signame: mbx5_soc_tl_d
        index: -1
      }
      {
        name: rst_cpu_n
        struct: logic
        type: uni
        act: req
        width: 1
        inst_name: rv_core_ibex
        index: -1
      }
      {
        name: ram_cfg_icache_tag
        struct: ram_1p_cfg
        package: prim_ram_1p_pkg
        type: uni
        act: rcv
        width: 1
        inst_name: rv_core_ibex
        index: -1
      }
      {
        name: ram_cfg_rsp_icache_tag
        struct: ram_1p_cfg_rsp
        package: prim_ram_1p_pkg
        type: uni
        act: req
        width:
        {
          name: ICacheNWays
          desc: Number of instruction cache ways
          param_type: int unsigned
          unpacked_dimensions: null
          default: 2
          local: false
          expose: true
          name_top: RvCoreIbexICacheNWays
        }
        inst_name: rv_core_ibex
        index: -1
      }
      {
        name: ram_cfg_icache_data
        struct: ram_1p_cfg
        package: prim_ram_1p_pkg
        type: uni
        act: rcv
        width: 1
        inst_name: rv_core_ibex
        index: -1
      }
      {
        name: ram_cfg_rsp_icache_data
        struct: ram_1p_cfg_rsp
        package: prim_ram_1p_pkg
        type: uni
        act: req
        width:
        {
          name: ICacheNWays
          desc: Number of instruction cache ways
          param_type: int unsigned
          unpacked_dimensions: null
          default: 2
          local: false
          expose: true
          name_top: RvCoreIbexICacheNWays
        }
        inst_name: rv_core_ibex
        index: -1
      }
      {
        name: hart_id
        struct: logic
        type: uni
        act: rcv
        width: 32
        inst_name: rv_core_ibex
        default: ""
        package: ""
        top_signame: rv_core_ibex_hart_id
        index: -1
      }
      {
        name: boot_addr
        struct: logic
        type: uni
        act: rcv
        width: 32
        inst_name: rv_core_ibex
        default: ""
        package: ""
        external: true
        top_signame: rv_boot_addr
        conn_type: false
        index: -1
      }
      {
        name: irq_software
        struct: logic
        type: uni
        act: rcv
        width: 1
        inst_name: rv_core_ibex
        default: ""
        package: ""
        top_signame: rv_plic_msip
        index: -1
      }
      {
        name: irq_timer
        struct: logic
        type: uni
        act: rcv
        width: 1
        inst_name: rv_core_ibex
        default: ""
        package: ""
        top_signame: rv_core_ibex_irq_timer
        index: -1
      }
      {
        name: irq_external
        struct: logic
        type: uni
        act: rcv
        width: 1
        inst_name: rv_core_ibex
        default: ""
        package: ""
        top_signame: rv_plic_irq
        index: -1
      }
      {
        name: esc_tx
        struct: esc_tx
        package: prim_esc_pkg
        type: uni
        act: rcv
        width: 1
        inst_name: rv_core_ibex
        default: ""
        external: true
        top_signame: rv_core_esc_tx
        conn_type: false
        index: -1
      }
      {
        name: esc_rx
        struct: esc_rx
        package: prim_esc_pkg
        type: uni
        act: req
        width: 1
        inst_name: rv_core_ibex
        default: ""
        external: true
        top_signame: rv_core_esc_rx
        conn_type: false
        index: -1
      }
      {
        name: debug_req
        struct: logic
        type: uni
        act: rcv
        width: 1
        inst_name: rv_core_ibex
        default: ""
        package: ""
        top_signame: rv_dm_debug_req
        index: -1
      }
      {
        name: crash_dump
        struct: cpu_crash_dump
        package: rv_core_ibex_pkg
        type: uni
        act: req
        width: 1
        inst_name: rv_core_ibex
        index: -1
      }
      {
        name: lc_cpu_en
        struct: lc_tx
        package: lc_ctrl_pkg
        type: uni
        act: rcv
        width: 1
        inst_name: rv_core_ibex
        default: ""
        external: true
        top_signame: rv_cpu_en
        conn_type: false
        index: -1
      }
      {
        name: pwrmgr_cpu_en
        struct: lc_tx
        package: lc_ctrl_pkg
        type: uni
        act: rcv
        width: 1
        inst_name: rv_core_ibex
        index: -1
      }
      {
        name: pwrmgr
        struct: cpu_pwrmgr
        package: rv_core_ibex_pkg
        type: uni
        act: req
        width: 1
        inst_name: rv_core_ibex
        index: -1
      }
      {
        name: nmi_wdog
        struct: logic
        type: uni
        act: rcv
        width: 1
        inst_name: rv_core_ibex
        default: ""
        package: ""
        top_signame: aon_timer_aon_nmi_wdog_timer_bark
        index: -1
      }
      {
        name: edn
        struct: edn
        package: edn_pkg
        type: req_rsp
        act: req
        width: 1
        inst_name: rv_core_ibex
        index: -1
      }
      {
        name: icache_otp_key
        struct: sram_otp_key
        package: otp_ctrl_pkg
        type: req_rsp
        act: req
        width: 1
        inst_name: rv_core_ibex
        index: -1
      }
      {
        name: fpga_info
        struct: logic
        type: uni
        act: rcv
        width: 32
        inst_name: rv_core_ibex
        default: ""
        package: ""
        external: true
        top_signame: fpga_info
        conn_type: false
        index: -1
      }
      {
        name: corei_tl_h
        struct: tl
        package: tlul_pkg
        type: req_rsp
        act: req
        width: 1
        inst_name: rv_core_ibex
        default: ""
        top_signame: pwc_main_tl_rv_core_ibex__corei
        index: -1
      }
      {
        name: cored_tl_h
        struct: tl
        package: tlul_pkg
        type: req_rsp
        act: req
        width: 1
        inst_name: rv_core_ibex
        default: ""
        top_signame: pwc_main_tl_rv_core_ibex__cored
        index: -1
      }
      {
        name: cfg_tl_d
        struct: tl
        package: tlul_pkg
        type: req_rsp
        act: rsp
        width: 1
        inst_name: rv_core_ibex
        default: ""
        end_idx: -1
        top_signame: rv_core_ibex_cfg_tl_d
        index: -1
      }
      {
        name: tl_rv_core_ibex__corei
        struct: tl
        package: tlul_pkg
        type: req_rsp
        act: rsp
        width: 1
        inst_name: pwc_main
        default: ""
        end_idx: -1
        top_signame: pwc_main_tl_rv_core_ibex__corei
        index: -1
      }
      {
        name: tl_rv_core_ibex__cored
        struct: tl
        package: tlul_pkg
        type: req_rsp
        act: rsp
        width: 1
        inst_name: pwc_main
        default: ""
        end_idx: -1
        top_signame: pwc_main_tl_rv_core_ibex__cored
        index: -1
      }
      {
        name: tl_rv_dm__sba
        struct: tl
        package: tlul_pkg
        type: req_rsp
        act: rsp
        width: 1
        inst_name: pwc_main
        default: ""
        end_idx: -1
        top_signame: pwc_main_tl_rv_dm__sba
        index: -1
      }
      {
        name: tl_dma__host
        struct: tl
        package: tlul_pkg
        type: req_rsp
        act: rsp
        width: 1
        inst_name: pwc_main
        default: ""
        end_idx: -1
        top_signame: pwc_main_tl_dma__host
        index: -1
      }
      {
        name: tl_mbx0__sram
        struct: tl
        package: tlul_pkg
        type: req_rsp
        act: rsp
        width: 1
        inst_name: pwc_main
        default: ""
        end_idx: -1
        top_signame: pwc_main_tl_mbx0__sram
        index: -1
      }
      {
        name: tl_mbx1__sram
        struct: tl
        package: tlul_pkg
        type: req_rsp
        act: rsp
        width: 1
        inst_name: pwc_main
        default: ""
        end_idx: -1
        top_signame: pwc_main_tl_mbx1__sram
        index: -1
      }
      {
        name: tl_mbx2__sram
        struct: tl
        package: tlul_pkg
        type: req_rsp
        act: rsp
        width: 1
        inst_name: pwc_main
        default: ""
        end_idx: -1
        top_signame: pwc_main_tl_mbx2__sram
        index: -1
      }
      {
        name: tl_mbx3__sram
        struct: tl
        package: tlul_pkg
        type: req_rsp
        act: rsp
        width: 1
        inst_name: pwc_main
        default: ""
        end_idx: -1
        top_signame: pwc_main_tl_mbx3__sram
        index: -1
      }
      {
        name: tl_mbx4__sram
        struct: tl
        package: tlul_pkg
        type: req_rsp
        act: rsp
        width: 1
        inst_name: pwc_main
        default: ""
        end_idx: -1
        top_signame: pwc_main_tl_mbx4__sram
        index: -1
      }
      {
        name: tl_mbx5__sram
        struct: tl
        package: tlul_pkg
        type: req_rsp
        act: rsp
        width: 1
        inst_name: pwc_main
        default: ""
        end_idx: -1
        top_signame: pwc_main_tl_mbx5__sram
        index: -1
      }
      {
        name: tl_rv_dm__regs
        struct: tl
        package: tlul_pkg
        type: req_rsp
        act: req
        width: 1
        inst_name: pwc_main
        default: ""
        top_signame: rv_dm_regs_tl_d
        index: -1
      }
      {
        name: tl_rv_dm__mem
        struct: tl
        package: tlul_pkg
        type: req_rsp
        act: req
        width: 1
        inst_name: pwc_main
        default: ""
        top_signame: rv_dm_mem_tl_d
        index: -1
      }
      {
        name: tl_pwc_peri
        struct: tl
        package: tlul_pkg
        type: req_rsp
        act: req
        width: 1
        inst_name: pwc_main
        default: ""
        end_idx: -1
        top_signame: pwc_main_tl_pwc_peri
        index: -1
      }
      {
        name: tl_soc_proxy__core
        struct: tl
        package: tlul_pkg
        type: req_rsp
        act: req
        width: 1
        inst_name: pwc_main
        default: ""
        top_signame: soc_proxy_core_tl
        index: -1
      }
      {
        name: tl_soc_proxy__ctn
        struct: tl
        package: tlul_pkg
        type: req_rsp
        act: req
        width: 1
        inst_name: pwc_main
        default: ""
        top_signame: soc_proxy_ctn_tl
        index: -1
      }
      {
        name: tl_rv_plic
        struct: tl
        package: tlul_pkg
        type: req_rsp
        act: req
        width: 1
        inst_name: pwc_main
        default: ""
        top_signame: rv_plic_tl
        index: -1
      }
      {
        name: tl_rv_core_ibex__cfg
        struct: tl
        package: tlul_pkg
        type: req_rsp
        act: req
        width: 1
        inst_name: pwc_main
        default: ""
        top_signame: rv_core_ibex_cfg_tl_d
        index: -1
      }
      {
        name: tl_sram_ctrl_main__regs
        struct: tl
        package: tlul_pkg
        type: req_rsp
        act: req
        width: 1
        inst_name: pwc_main
        default: ""
        top_signame: sram_ctrl_main_regs_tl
        index: -1
      }
      {
        name: tl_sram_ctrl_main__ram
        struct: tl
        package: tlul_pkg
        type: req_rsp
        act: req
        width: 1
        inst_name: pwc_main
        default: ""
        top_signame: sram_ctrl_main_ram_tl
        index: -1
      }
      {
        name: tl_sram_ctrl_mbox__regs
        struct: tl
        package: tlul_pkg
        type: req_rsp
        act: req
        width: 1
        inst_name: pwc_main
        default: ""
        top_signame: sram_ctrl_mbox_regs_tl
        index: -1
      }
      {
        name: tl_sram_ctrl_mbox__ram
        struct: tl
        package: tlul_pkg
        type: req_rsp
        act: req
        width: 1
        inst_name: pwc_main
        default: ""
        top_signame: sram_ctrl_mbox_ram_tl
        index: -1
      }
      {
        name: tl_dma
        struct: tl
        package: tlul_pkg
        type: req_rsp
        act: req
        width: 1
        inst_name: pwc_main
        default: ""
        top_signame: dma_tl_d
        index: -1
      }
      {
        name: tl_mbx0__core
        struct: tl
        package: tlul_pkg
        type: req_rsp
        act: req
        width: 1
        inst_name: pwc_main
        default: ""
        top_signame: mbx0_core_tl_d
        index: -1
      }
      {
        name: tl_mbx1__core
        struct: tl
        package: tlul_pkg
        type: req_rsp
        act: req
        width: 1
        inst_name: pwc_main
        default: ""
        top_signame: mbx1_core_tl_d
        index: -1
      }
      {
        name: tl_mbx2__core
        struct: tl
        package: tlul_pkg
        type: req_rsp
        act: req
        width: 1
        inst_name: pwc_main
        default: ""
        top_signame: mbx2_core_tl_d
        index: -1
      }
      {
        name: tl_mbx3__core
        struct: tl
        package: tlul_pkg
        type: req_rsp
        act: req
        width: 1
        inst_name: pwc_main
        default: ""
        top_signame: mbx3_core_tl_d
        index: -1
      }
      {
        name: tl_mbx4__core
        struct: tl
        package: tlul_pkg
        type: req_rsp
        act: req
        width: 1
        inst_name: pwc_main
        default: ""
        top_signame: mbx4_core_tl_d
        index: -1
      }
      {
        name: tl_mbx5__core
        struct: tl
        package: tlul_pkg
        type: req_rsp
        act: req
        width: 1
        inst_name: pwc_main
        default: ""
        top_signame: mbx5_core_tl_d
        index: -1
      }
      {
        name: tl_pwc_main
        struct: tl
        package: tlul_pkg
        type: req_rsp
        act: rsp
        width: 1
        inst_name: pwc_peri
        default: ""
        top_signame: pwc_main_tl_pwc_peri
        index: -1
      }
      {
        name: tl_gpio
        struct: tl
        package: tlul_pkg
        type: req_rsp
        act: req
        width: 1
        inst_name: pwc_peri
        default: ""
        top_signame: gpio_tl
        index: -1
      }
      {
        name: tl_rv_timer
        struct: tl
        package: tlul_pkg
        type: req_rsp
        act: req
        width: 1
        inst_name: pwc_peri
        default: ""
        top_signame: rv_timer_tl
        index: -1
      }
      {
        name: tl_sram_ctrl_ret_aon__regs
        struct: tl
        package: tlul_pkg
        type: req_rsp
        act: req
        width: 1
        inst_name: pwc_peri
        default: ""
        top_signame: sram_ctrl_ret_aon_regs_tl
        index: -1
      }
      {
        name: tl_sram_ctrl_ret_aon__ram
        struct: tl
        package: tlul_pkg
        type: req_rsp
        act: req
        width: 1
        inst_name: pwc_peri
        default: ""
        top_signame: sram_ctrl_ret_aon_ram_tl
        index: -1
      }
      {
        name: tl_aon_timer_aon
        struct: tl
        package: tlul_pkg
        type: req_rsp
        act: req
        width: 1
        inst_name: pwc_peri
        default: ""
        top_signame: aon_timer_aon_tl
        index: -1
      }
      {
        name: tl_pwc_mbx
        struct: tl
        package: tlul_pkg
        type: req_rsp
        act: rsp
        width: 1
        inst_name: pwc_mbx
        default: ""
        external: true
        top_signame: mbx_tl
        conn_type: false
        index: -1
      }
      {
        name: tl_mbx0__soc
        struct: tl
        package: tlul_pkg
        type: req_rsp
        act: req
        width: 1
        inst_name: pwc_mbx
        default: ""
        top_signame: mbx0_soc_tl_d
        index: -1
      }
      {
        name: tl_mbx1__soc
        struct: tl
        package: tlul_pkg
        type: req_rsp
        act: req
        width: 1
        inst_name: pwc_mbx
        default: ""
        top_signame: mbx1_soc_tl_d
        index: -1
      }
      {
        name: tl_mbx2__soc
        struct: tl
        package: tlul_pkg
        type: req_rsp
        act: req
        width: 1
        inst_name: pwc_mbx
        default: ""
        top_signame: mbx2_soc_tl_d
        index: -1
      }
      {
        name: tl_mbx3__soc
        struct: tl
        package: tlul_pkg
        type: req_rsp
        act: req
        width: 1
        inst_name: pwc_mbx
        default: ""
        top_signame: mbx3_soc_tl_d
        index: -1
      }
      {
        name: tl_mbx4__soc
        struct: tl
        package: tlul_pkg
        type: req_rsp
        act: req
        width: 1
        inst_name: pwc_mbx
        default: ""
        top_signame: mbx4_soc_tl_d
        index: -1
      }
      {
        name: tl_mbx5__soc
        struct: tl
        package: tlul_pkg
        type: req_rsp
        act: req
        width: 1
        inst_name: pwc_mbx
        default: ""
        top_signame: mbx5_soc_tl_d
        index: -1
      }
    ]
    external:
    [
      {
        package: dma_pkg
        struct: sys_req
        signame: dma_sys_req_o
        width: 1
        type: req_rsp
        default: ""
        direction: out
        conn_type: false
        index: -1
        netname: dma_sys_req
      }
      {
        package: dma_pkg
        struct: sys_rsp
        signame: dma_sys_rsp_i
        width: 1
        type: req_rsp
        default: ""
        direction: in
        conn_type: false
        index: -1
        netname: dma_sys_rsp
      }
      {
        package: tlul_pkg
        struct: tl_h2d
        signame: dma_ctn_tl_h2d_o
        width: 1
        type: uni
        default: ""
        direction: out
        conn_type: false
        index: -1
        netname: dma_ctn_tl_h2d
      }
      {
        package: tlul_pkg
        struct: tl_d2h
        signame: dma_ctn_tl_d2h_i
        width: 1
        type: uni
        default: ""
        direction: in
        conn_type: false
        index: -1
        netname: dma_ctn_tl_d2h
      }
      {
        package: tlul_pkg
        struct: tl_h2d
        signame: mbx_tl_req_i
        width: 1
        type: req_rsp
        default: ""
        direction: in
        conn_type: false
        index: -1
        netname: mbx_tl_h2d
      }
      {
        package: tlul_pkg
        struct: tl_d2h
        signame: mbx_tl_rsp_o
        width: 1
        type: req_rsp
        default: ""
        direction: out
        conn_type: false
        index: -1
        netname: mbx_tl_d2h
      }
      {
        package: rv_dm_pkg
        struct: next_dm_addr
        signame: rv_dm_next_dm_addr_i
        width: 1
        type: uni
        default: "'0"
        direction: in
        conn_type: false
        index: -1
        netname: rv_dm_next_dm_addr
      }
      {
        package: tlul_pkg
        struct: tl_h2d
        signame: rv_dm_dbg_req_i
        width: 1
        type: req_rsp
        default: ""
        direction: in
        conn_type: false
        index: -1
        netname: rv_dm_dbg_h2d
      }
      {
        package: tlul_pkg
        struct: tl_d2h
        signame: rv_dm_dbg_rsp_o
        width: 1
        type: req_rsp
        default: ""
        direction: out
        conn_type: false
        index: -1
        netname: rv_dm_dbg_d2h
      }
      {
        package: ""
        struct: logic
        signame: fpga_info_i
        width: 32
        type: uni
        default: ""
        direction: in
        conn_type: false
        index: -1
        netname: fpga_info
      }
      {
        package: tlul_pkg
        struct: tl_h2d
        signame: ctn_tl_h2d_o
        width: 1
        type: uni
        default: ""
        direction: out
        conn_type: false
        index: -1
        netname: ctn_tl_h2d
      }
      {
        package: ""
        struct: logic
        signame: rv_boot_addr_i
        width: 32
        type: uni
        default: ""
        direction: in
        conn_type: false
        index: -1
        netname: rv_boot_addr
      }
      {
        package: lc_ctrl_pkg
        struct: lc_tx
        signame: rv_cpu_en_i
        width: 1
        type: uni
        default: ""
        direction: in
        conn_type: false
        index: -1
        netname: rv_cpu_en
      }
      {
        package: prim_esc_pkg
        struct: esc_rx
        signame: rv_core_esc_rx_o
        width: 1
        type: uni
        default: ""
        direction: out
        conn_type: false
        index: -1
        netname: rv_core_esc_rx
      }
      {
        package: prim_esc_pkg
        struct: esc_tx
        signame: rv_core_esc_tx_i
        width: 1
        type: uni
        default: ""
        direction: in
        conn_type: false
        index: -1
        netname: rv_core_esc_tx
      }
      {
        package: tlul_pkg
        struct: tl_d2h
        signame: ctn_tl_d2h_i
        width: 1
        type: uni
        default: ""
        direction: in
        conn_type: false
        index: -1
        netname: ctn_tl_d2h
      }
      {
        package: lc_ctrl_pkg
        struct: lc_tx
        signame: lc_hw_debug_en_ext_i
        width: 1
        type: uni
        default: lc_ctrl_pkg::Off
        direction: in
        conn_type: false
        index: -1
        netname: lc_hw_debug_en_ext
      }
      {
        package: lc_ctrl_pkg
        struct: lc_tx
        signame: lc_escalate_en_ext_i
        width: 1
        type: uni
        default: lc_ctrl_pkg::Off
        direction: in
        conn_type: false
        index: -1
        netname: lc_escalate_en_ext
      }
      {
        package: ""
        struct: logic
        signame: soc_lsio_trigger_i
        width: 8
        type: uni
        default: ""
        direction: in
        conn_type: false
        index: -1
        netname: soc_lsio_trigger
      }
      {
        package: lc_ctrl_pkg
        struct: lc_tx
        signame: lc_check_byp_en_i
        width: 1
        type: uni
        default: lc_ctrl_pkg::Off
        direction: in
        conn_type: false
        index: -1
        netname: lc_check_byp_en
      }
      {
        package: prim_ram_1p_pkg
        struct: ram_1p_cfg
        signame: sram_ctrl_ret_aon_ram_1p_cfg_i
        width:
        {
          name: NumRamInst
          desc: Number of internal RAM instances. Must be the same as ceil(MemSizeRam / InstSize) .
          param_type: int
          unpacked_dimensions: null
          default: 1
          local: false
          expose: true
          name_top: SramCtrlRetAonNumRamInst
        }
        type: uni
        default: "'0"
        direction: in
        conn_type: false
        index: -1
        netname: sram_ctrl_ret_aon_ram_1p_cfg
      }
      {
        package: prim_ram_1p_pkg
        struct: ram_1p_cfg_rsp
        signame: sram_ctrl_ret_aon_ram_1p_cfg_rsp_o
        width:
        {
          name: NumRamInst
          desc: Number of internal RAM instances. Must be the same as ceil(MemSizeRam / InstSize) .
          param_type: int
          unpacked_dimensions: null
          default: 1
          local: false
          expose: true
          name_top: SramCtrlRetAonNumRamInst
        }
        type: uni
        default: "'0"
        direction: out
        conn_type: false
        index: -1
        netname: sram_ctrl_ret_aon_ram_1p_cfg_rsp
      }
      {
        package: prim_ram_1p_pkg
        struct: ram_1p_cfg
        signame: sram_ctrl_main_ram_1p_cfg_i
        width:
        {
          name: NumRamInst
          desc: Number of internal RAM instances. Must be the same as ceil(MemSizeRam / InstSize) .
          param_type: int
          unpacked_dimensions: null
          default: 1
          local: false
          expose: true
          name_top: SramCtrlMainNumRamInst
        }
        type: uni
        default: "'0"
        direction: in
        conn_type: false
        index: -1
        netname: sram_ctrl_main_ram_1p_cfg
      }
      {
        package: prim_ram_1p_pkg
        struct: ram_1p_cfg_rsp
        signame: sram_ctrl_main_ram_1p_cfg_rsp_o
        width:
        {
          name: NumRamInst
          desc: Number of internal RAM instances. Must be the same as ceil(MemSizeRam / InstSize) .
          param_type: int
          unpacked_dimensions: null
          default: 1
          local: false
          expose: true
          name_top: SramCtrlMainNumRamInst
        }
        type: uni
        default: "'0"
        direction: out
        conn_type: false
        index: -1
        netname: sram_ctrl_main_ram_1p_cfg_rsp
      }
      {
        package: prim_ram_1p_pkg
        struct: ram_1p_cfg
        signame: sram_ctrl_mbox_ram_1p_cfg_i
        width:
        {
          name: NumRamInst
          desc: Number of internal RAM instances. Must be the same as ceil(MemSizeRam / InstSize) .
          param_type: int
          unpacked_dimensions: null
          default: 1
          local: false
          expose: true
          name_top: SramCtrlMboxNumRamInst
        }
        type: uni
        default: "'0"
        direction: in
        conn_type: false
        index: -1
        netname: sram_ctrl_mbox_ram_1p_cfg
      }
      {
        package: prim_ram_1p_pkg
        struct: ram_1p_cfg_rsp
        signame: sram_ctrl_mbox_ram_1p_cfg_rsp_o
        width:
        {
          name: NumRamInst
          desc: Number of internal RAM instances. Must be the same as ceil(MemSizeRam / InstSize) .
          param_type: int
          unpacked_dimensions: null
          default: 1
          local: false
          expose: true
          name_top: SramCtrlMboxNumRamInst
        }
        type: uni
        default: "'0"
        direction: out
        conn_type: false
        index: -1
        netname: sram_ctrl_mbox_ram_1p_cfg_rsp
      }
    ]
    definitions:
    [
      {
        package: ""
        struct: logic
        signame: aon_timer_aon_nmi_wdog_timer_bark
        width: 1
        type: uni
        end_idx: -1
        act: req
        suffix: ""
        default: 1'b0
      }
      {
        package: dma_pkg
        struct: lsio_trigger
        signame: dma_lsio_trigger
        width: 1
        type: uni
        end_idx: -1
        act: rcv
        suffix: ""
        default: dma_pkg::LSIO_TRIGGER_DEFAULT
      }
      {
        package: ""
        struct: logic
        signame: rv_plic_msip
        width: 1
        type: uni
        end_idx: -1
        act: req
        suffix: ""
        default: "'0"
      }
      {
        package: ""
        struct: logic
        signame: rv_plic_irq
        width: 1
        type: uni
        end_idx: -1
        act: req
        suffix: ""
        default: "'0"
      }
      {
        package: ""
        struct: logic [rv_dm_reg_pkg::NrHarts-1:0]
        signame: rv_dm_debug_req
        width: 1
        type: uni
        end_idx: -1
        act: req
        suffix: ""
        default: "'0"
      }
      {
        package: lc_ctrl_pkg
        struct: lc_tx
        signame: soc_proxy_lc_hw_debug_en
        width: 1
        type: uni
        end_idx: -1
        act: req
        suffix: ""
        default: lc_ctrl_pkg::Off
      }
      {
        package: lc_ctrl_pkg
        struct: lc_tx
        signame: soc_proxy_lc_escalate_en
        width: 1
        type: uni
        end_idx: -1
        act: req
        suffix: ""
        default: lc_ctrl_pkg::Off
      }
      {
        package: prim_mubi_pkg
        struct: mubi8
        signame: sram_ctrl_main_otp_en_sram_ifetch
        width: 1
        type: uni
        end_idx: -1
        act: rcv
        suffix: ""
        default: prim_mubi_pkg::MuBi8False
      }
      {
        package: tlul_pkg
        struct: tl_h2d
        signame: pwc_main_tl_rv_core_ibex__corei_req
        width: 1
        type: req_rsp
        end_idx: -1
        act: rsp
        suffix: req
        default: tlul_pkg::TL_H2D_DEFAULT
      }
      {
        package: tlul_pkg
        struct: tl_d2h
        signame: pwc_main_tl_rv_core_ibex__corei_rsp
        width: 1
        type: req_rsp
        end_idx: -1
        act: rsp
        suffix: rsp
        default: ""
      }
      {
        package: tlul_pkg
        struct: tl_h2d
        signame: pwc_main_tl_rv_core_ibex__cored_req
        width: 1
        type: req_rsp
        end_idx: -1
        act: rsp
        suffix: req
        default: tlul_pkg::TL_H2D_DEFAULT
      }
      {
        package: tlul_pkg
        struct: tl_d2h
        signame: pwc_main_tl_rv_core_ibex__cored_rsp
        width: 1
        type: req_rsp
        end_idx: -1
        act: rsp
        suffix: rsp
        default: ""
      }
      {
        package: tlul_pkg
        struct: tl_h2d
        signame: pwc_main_tl_rv_dm__sba_req
        width: 1
        type: req_rsp
        end_idx: -1
        act: rsp
        suffix: req
        default: tlul_pkg::TL_H2D_DEFAULT
      }
      {
        package: tlul_pkg
        struct: tl_d2h
        signame: pwc_main_tl_rv_dm__sba_rsp
        width: 1
        type: req_rsp
        end_idx: -1
        act: rsp
        suffix: rsp
        default: ""
      }
      {
        package: tlul_pkg
        struct: tl_h2d
        signame: rv_dm_regs_tl_d_req
        width: 1
        type: req_rsp
        end_idx: -1
        act: rsp
        suffix: req
        default: tlul_pkg::TL_H2D_DEFAULT
      }
      {
        package: tlul_pkg
        struct: tl_d2h
        signame: rv_dm_regs_tl_d_rsp
        width: 1
        type: req_rsp
        end_idx: -1
        act: rsp
        suffix: rsp
        default: ""
      }
      {
        package: tlul_pkg
        struct: tl_h2d
        signame: rv_dm_mem_tl_d_req
        width: 1
        type: req_rsp
        end_idx: -1
        act: rsp
        suffix: req
        default: tlul_pkg::TL_H2D_DEFAULT
      }
      {
        package: tlul_pkg
        struct: tl_d2h
        signame: rv_dm_mem_tl_d_rsp
        width: 1
        type: req_rsp
        end_idx: -1
        act: rsp
        suffix: rsp
        default: ""
      }
      {
        package: tlul_pkg
        struct: tl_h2d
        signame: pwc_main_tl_pwc_peri_req
        width: 1
        type: req_rsp
        end_idx: -1
        act: req
        suffix: req
        default: ""
      }
      {
        package: tlul_pkg
        struct: tl_d2h
        signame: pwc_main_tl_pwc_peri_rsp
        width: 1
        type: req_rsp
        end_idx: -1
        act: req
        suffix: rsp
        default: tlul_pkg::TL_D2H_DEFAULT
      }
      {
        package: tlul_pkg
        struct: tl_h2d
        signame: soc_proxy_core_tl_req
        width: 1
        type: req_rsp
        end_idx: -1
        act: rsp
        suffix: req
        default: tlul_pkg::TL_H2D_DEFAULT
      }
      {
        package: tlul_pkg
        struct: tl_d2h
        signame: soc_proxy_core_tl_rsp
        width: 1
        type: req_rsp
        end_idx: -1
        act: rsp
        suffix: rsp
        default: ""
      }
      {
        package: tlul_pkg
        struct: tl_h2d
        signame: soc_proxy_ctn_tl_req
        width: 1
        type: req_rsp
        end_idx: -1
        act: rsp
        suffix: req
        default: tlul_pkg::TL_H2D_DEFAULT
      }
      {
        package: tlul_pkg
        struct: tl_d2h
        signame: soc_proxy_ctn_tl_rsp
        width: 1
        type: req_rsp
        end_idx: -1
        act: rsp
        suffix: rsp
        default: ""
      }
      {
        package: tlul_pkg
        struct: tl_h2d
        signame: rv_plic_tl_req
        width: 1
        type: req_rsp
        end_idx: -1
        act: rsp
        suffix: req
        default: tlul_pkg::TL_H2D_DEFAULT
      }
      {
        package: tlul_pkg
        struct: tl_d2h
        signame: rv_plic_tl_rsp
        width: 1
        type: req_rsp
        end_idx: -1
        act: rsp
        suffix: rsp
        default: ""
      }
      {
        package: tlul_pkg
        struct: tl_h2d
        signame: rv_core_ibex_cfg_tl_d_req
        width: 1
        type: req_rsp
        end_idx: -1
        act: rsp
        suffix: req
        default: tlul_pkg::TL_H2D_DEFAULT
      }
      {
        package: tlul_pkg
        struct: tl_d2h
        signame: rv_core_ibex_cfg_tl_d_rsp
        width: 1
        type: req_rsp
        end_idx: -1
        act: rsp
        suffix: rsp
        default: ""
      }
      {
        package: tlul_pkg
        struct: tl_h2d
        signame: sram_ctrl_main_regs_tl_req
        width: 1
        type: req_rsp
        end_idx: -1
        act: rsp
        suffix: req
        default: tlul_pkg::TL_H2D_DEFAULT
      }
      {
        package: tlul_pkg
        struct: tl_d2h
        signame: sram_ctrl_main_regs_tl_rsp
        width: 1
        type: req_rsp
        end_idx: -1
        act: rsp
        suffix: rsp
        default: ""
      }
      {
        package: tlul_pkg
        struct: tl_h2d
        signame: sram_ctrl_main_ram_tl_req
        width: 1
        type: req_rsp
        end_idx: -1
        act: rsp
        suffix: req
        default: tlul_pkg::TL_H2D_DEFAULT
      }
      {
        package: tlul_pkg
        struct: tl_d2h
        signame: sram_ctrl_main_ram_tl_rsp
        width: 1
        type: req_rsp
        end_idx: -1
        act: rsp
        suffix: rsp
        default: ""
      }
      {
        package: tlul_pkg
        struct: tl_h2d
        signame: sram_ctrl_mbox_regs_tl_req
        width: 1
        type: req_rsp
        end_idx: -1
        act: rsp
        suffix: req
        default: tlul_pkg::TL_H2D_DEFAULT
      }
      {
        package: tlul_pkg
        struct: tl_d2h
        signame: sram_ctrl_mbox_regs_tl_rsp
        width: 1
        type: req_rsp
        end_idx: -1
        act: rsp
        suffix: rsp
        default: ""
      }
      {
        package: tlul_pkg
        struct: tl_h2d
        signame: sram_ctrl_mbox_ram_tl_req
        width: 1
        type: req_rsp
        end_idx: -1
        act: rsp
        suffix: req
        default: tlul_pkg::TL_H2D_DEFAULT
      }
      {
        package: tlul_pkg
        struct: tl_d2h
        signame: sram_ctrl_mbox_ram_tl_rsp
        width: 1
        type: req_rsp
        end_idx: -1
        act: rsp
        suffix: rsp
        default: ""
      }
      {
        package: tlul_pkg
        struct: tl_h2d
        signame: dma_tl_d_req
        width: 1
        type: req_rsp
        end_idx: -1
        act: rsp
        suffix: req
        default: tlul_pkg::TL_H2D_DEFAULT
      }
      {
        package: tlul_pkg
        struct: tl_d2h
        signame: dma_tl_d_rsp
        width: 1
        type: req_rsp
        end_idx: -1
        act: rsp
        suffix: rsp
        default: ""
      }
      {
        package: tlul_pkg
        struct: tl_h2d
        signame: pwc_main_tl_dma__host_req
        width: 1
        type: req_rsp
        end_idx: -1
        act: rsp
        suffix: req
        default: tlul_pkg::TL_H2D_DEFAULT
      }
      {
        package: tlul_pkg
        struct: tl_d2h
        signame: pwc_main_tl_dma__host_rsp
        width: 1
        type: req_rsp
        end_idx: -1
        act: rsp
        suffix: rsp
        default: ""
      }
      {
        package: tlul_pkg
        struct: tl_h2d
        signame: mbx0_core_tl_d_req
        width: 1
        type: req_rsp
        end_idx: -1
        act: rsp
        suffix: req
        default: tlul_pkg::TL_H2D_DEFAULT
      }
      {
        package: tlul_pkg
        struct: tl_d2h
        signame: mbx0_core_tl_d_rsp
        width: 1
        type: req_rsp
        end_idx: -1
        act: rsp
        suffix: rsp
        default: ""
      }
      {
        package: tlul_pkg
        struct: tl_h2d
        signame: pwc_main_tl_mbx0__sram_req
        width: 1
        type: req_rsp
        end_idx: -1
        act: rsp
        suffix: req
        default: tlul_pkg::TL_H2D_DEFAULT
      }
      {
        package: tlul_pkg
        struct: tl_d2h
        signame: pwc_main_tl_mbx0__sram_rsp
        width: 1
        type: req_rsp
        end_idx: -1
        act: rsp
        suffix: rsp
        default: ""
      }
      {
        package: tlul_pkg
        struct: tl_h2d
        signame: mbx1_core_tl_d_req
        width: 1
        type: req_rsp
        end_idx: -1
        act: rsp
        suffix: req
        default: tlul_pkg::TL_H2D_DEFAULT
      }
      {
        package: tlul_pkg
        struct: tl_d2h
        signame: mbx1_core_tl_d_rsp
        width: 1
        type: req_rsp
        end_idx: -1
        act: rsp
        suffix: rsp
        default: ""
      }
      {
        package: tlul_pkg
        struct: tl_h2d
        signame: pwc_main_tl_mbx1__sram_req
        width: 1
        type: req_rsp
        end_idx: -1
        act: rsp
        suffix: req
        default: tlul_pkg::TL_H2D_DEFAULT
      }
      {
        package: tlul_pkg
        struct: tl_d2h
        signame: pwc_main_tl_mbx1__sram_rsp
        width: 1
        type: req_rsp
        end_idx: -1
        act: rsp
        suffix: rsp
        default: ""
      }
      {
        package: tlul_pkg
        struct: tl_h2d
        signame: mbx2_core_tl_d_req
        width: 1
        type: req_rsp
        end_idx: -1
        act: rsp
        suffix: req
        default: tlul_pkg::TL_H2D_DEFAULT
      }
      {
        package: tlul_pkg
        struct: tl_d2h
        signame: mbx2_core_tl_d_rsp
        width: 1
        type: req_rsp
        end_idx: -1
        act: rsp
        suffix: rsp
        default: ""
      }
      {
        package: tlul_pkg
        struct: tl_h2d
        signame: pwc_main_tl_mbx2__sram_req
        width: 1
        type: req_rsp
        end_idx: -1
        act: rsp
        suffix: req
        default: tlul_pkg::TL_H2D_DEFAULT
      }
      {
        package: tlul_pkg
        struct: tl_d2h
        signame: pwc_main_tl_mbx2__sram_rsp
        width: 1
        type: req_rsp
        end_idx: -1
        act: rsp
        suffix: rsp
        default: ""
      }
      {
        package: tlul_pkg
        struct: tl_h2d
        signame: mbx3_core_tl_d_req
        width: 1
        type: req_rsp
        end_idx: -1
        act: rsp
        suffix: req
        default: tlul_pkg::TL_H2D_DEFAULT
      }
      {
        package: tlul_pkg
        struct: tl_d2h
        signame: mbx3_core_tl_d_rsp
        width: 1
        type: req_rsp
        end_idx: -1
        act: rsp
        suffix: rsp
        default: ""
      }
      {
        package: tlul_pkg
        struct: tl_h2d
        signame: pwc_main_tl_mbx3__sram_req
        width: 1
        type: req_rsp
        end_idx: -1
        act: rsp
        suffix: req
        default: tlul_pkg::TL_H2D_DEFAULT
      }
      {
        package: tlul_pkg
        struct: tl_d2h
        signame: pwc_main_tl_mbx3__sram_rsp
        width: 1
        type: req_rsp
        end_idx: -1
        act: rsp
        suffix: rsp
        default: ""
      }
      {
        package: tlul_pkg
        struct: tl_h2d
        signame: mbx4_core_tl_d_req
        width: 1
        type: req_rsp
        end_idx: -1
        act: rsp
        suffix: req
        default: tlul_pkg::TL_H2D_DEFAULT
      }
      {
        package: tlul_pkg
        struct: tl_d2h
        signame: mbx4_core_tl_d_rsp
        width: 1
        type: req_rsp
        end_idx: -1
        act: rsp
        suffix: rsp
        default: ""
      }
      {
        package: tlul_pkg
        struct: tl_h2d
        signame: pwc_main_tl_mbx4__sram_req
        width: 1
        type: req_rsp
        end_idx: -1
        act: rsp
        suffix: req
        default: tlul_pkg::TL_H2D_DEFAULT
      }
      {
        package: tlul_pkg
        struct: tl_d2h
        signame: pwc_main_tl_mbx4__sram_rsp
        width: 1
        type: req_rsp
        end_idx: -1
        act: rsp
        suffix: rsp
        default: ""
      }
      {
        package: tlul_pkg
        struct: tl_h2d
        signame: mbx5_core_tl_d_req
        width: 1
        type: req_rsp
        end_idx: -1
        act: rsp
        suffix: req
        default: tlul_pkg::TL_H2D_DEFAULT
      }
      {
        package: tlul_pkg
        struct: tl_d2h
        signame: mbx5_core_tl_d_rsp
        width: 1
        type: req_rsp
        end_idx: -1
        act: rsp
        suffix: rsp
        default: ""
      }
      {
        package: tlul_pkg
        struct: tl_h2d
        signame: pwc_main_tl_mbx5__sram_req
        width: 1
        type: req_rsp
        end_idx: -1
        act: rsp
        suffix: req
        default: tlul_pkg::TL_H2D_DEFAULT
      }
      {
        package: tlul_pkg
        struct: tl_d2h
        signame: pwc_main_tl_mbx5__sram_rsp
        width: 1
        type: req_rsp
        end_idx: -1
        act: rsp
        suffix: rsp
        default: ""
      }
      {
        package: tlul_pkg
        struct: tl_h2d
        signame: gpio_tl_req
        width: 1
        type: req_rsp
        end_idx: -1
        act: rsp
        suffix: req
        default: tlul_pkg::TL_H2D_DEFAULT
      }
      {
        package: tlul_pkg
        struct: tl_d2h
        signame: gpio_tl_rsp
        width: 1
        type: req_rsp
        end_idx: -1
        act: rsp
        suffix: rsp
        default: ""
      }
      {
        package: tlul_pkg
        struct: tl_h2d
        signame: rv_timer_tl_req
        width: 1
        type: req_rsp
        end_idx: -1
        act: rsp
        suffix: req
        default: tlul_pkg::TL_H2D_DEFAULT
      }
      {
        package: tlul_pkg
        struct: tl_d2h
        signame: rv_timer_tl_rsp
        width: 1
        type: req_rsp
        end_idx: -1
        act: rsp
        suffix: rsp
        default: ""
      }
      {
        package: tlul_pkg
        struct: tl_h2d
        signame: sram_ctrl_ret_aon_regs_tl_req
        width: 1
        type: req_rsp
        end_idx: -1
        act: rsp
        suffix: req
        default: tlul_pkg::TL_H2D_DEFAULT
      }
      {
        package: tlul_pkg
        struct: tl_d2h
        signame: sram_ctrl_ret_aon_regs_tl_rsp
        width: 1
        type: req_rsp
        end_idx: -1
        act: rsp
        suffix: rsp
        default: ""
      }
      {
        package: tlul_pkg
        struct: tl_h2d
        signame: sram_ctrl_ret_aon_ram_tl_req
        width: 1
        type: req_rsp
        end_idx: -1
        act: rsp
        suffix: req
        default: tlul_pkg::TL_H2D_DEFAULT
      }
      {
        package: tlul_pkg
        struct: tl_d2h
        signame: sram_ctrl_ret_aon_ram_tl_rsp
        width: 1
        type: req_rsp
        end_idx: -1
        act: rsp
        suffix: rsp
        default: ""
      }
      {
        package: tlul_pkg
        struct: tl_h2d
        signame: aon_timer_aon_tl_req
        width: 1
        type: req_rsp
        end_idx: -1
        act: rsp
        suffix: req
        default: tlul_pkg::TL_H2D_DEFAULT
      }
      {
        package: tlul_pkg
        struct: tl_d2h
        signame: aon_timer_aon_tl_rsp
        width: 1
        type: req_rsp
        end_idx: -1
        act: rsp
        suffix: rsp
        default: ""
      }
      {
        package: tlul_pkg
        struct: tl_h2d
        signame: mbx0_soc_tl_d_req
        width: 1
        type: req_rsp
        end_idx: -1
        act: rsp
        suffix: req
        default: tlul_pkg::TL_H2D_DEFAULT
      }
      {
        package: tlul_pkg
        struct: tl_d2h
        signame: mbx0_soc_tl_d_rsp
        width: 1
        type: req_rsp
        end_idx: -1
        act: rsp
        suffix: rsp
        default: ""
      }
      {
        package: tlul_pkg
        struct: tl_h2d
        signame: mbx1_soc_tl_d_req
        width: 1
        type: req_rsp
        end_idx: -1
        act: rsp
        suffix: req
        default: tlul_pkg::TL_H2D_DEFAULT
      }
      {
        package: tlul_pkg
        struct: tl_d2h
        signame: mbx1_soc_tl_d_rsp
        width: 1
        type: req_rsp
        end_idx: -1
        act: rsp
        suffix: rsp
        default: ""
      }
      {
        package: tlul_pkg
        struct: tl_h2d
        signame: mbx2_soc_tl_d_req
        width: 1
        type: req_rsp
        end_idx: -1
        act: rsp
        suffix: req
        default: tlul_pkg::TL_H2D_DEFAULT
      }
      {
        package: tlul_pkg
        struct: tl_d2h
        signame: mbx2_soc_tl_d_rsp
        width: 1
        type: req_rsp
        end_idx: -1
        act: rsp
        suffix: rsp
        default: ""
      }
      {
        package: tlul_pkg
        struct: tl_h2d
        signame: mbx3_soc_tl_d_req
        width: 1
        type: req_rsp
        end_idx: -1
        act: rsp
        suffix: req
        default: tlul_pkg::TL_H2D_DEFAULT
      }
      {
        package: tlul_pkg
        struct: tl_d2h
        signame: mbx3_soc_tl_d_rsp
        width: 1
        type: req_rsp
        end_idx: -1
        act: rsp
        suffix: rsp
        default: ""
      }
      {
        package: tlul_pkg
        struct: tl_h2d
        signame: mbx4_soc_tl_d_req
        width: 1
        type: req_rsp
        end_idx: -1
        act: rsp
        suffix: req
        default: tlul_pkg::TL_H2D_DEFAULT
      }
      {
        package: tlul_pkg
        struct: tl_d2h
        signame: mbx4_soc_tl_d_rsp
        width: 1
        type: req_rsp
        end_idx: -1
        act: rsp
        suffix: rsp
        default: ""
      }
      {
        package: tlul_pkg
        struct: tl_h2d
        signame: mbx5_soc_tl_d_req
        width: 1
        type: req_rsp
        end_idx: -1
        act: rsp
        suffix: req
        default: tlul_pkg::TL_H2D_DEFAULT
      }
      {
        package: tlul_pkg
        struct: tl_d2h
        signame: mbx5_soc_tl_d_rsp
        width: 1
        type: req_rsp
        end_idx: -1
        act: rsp
        suffix: rsp
        default: ""
      }
      {
        package: ""
        struct: logic
        signame: rv_core_ibex_irq_timer
        width: 1
        type: uni
        end_idx: -1
        default: ""
      }
      {
        package: ""
        struct: logic
        signame: rv_core_ibex_hart_id
        width: 32
        type: uni
        end_idx: -1
        default: ""
      }
    ]
  }
}
