// Copyright lowRISC contributors (OpenTitan project).
// Licensed under the Apache License, Version 2.0, see LICENSE for details.
// SPDX-License-Identifier: Apache-2.0
//
// TOP Pwc configuration
{ name: "pwc",
  type: "top",

  // 32-bit datawidth
  datawidth: "32",

  // Enable RACL on PWC based on the following configuration
  racl_config: '../../top_darjeeling/data/rivos-racl/racl.hjson'

  // Power information for the design
  power: {
    // Power domains supported by the design
    // Aon represents domain aon
    // 0 represents domain 0
    domains: ["0"],

    // Default power domain used for the design
    default: "0"

    // Wait for external resets for integrated OpenTitan
    wait_for_external_reset: true
  },

  // List of unmanaged external clocks
  unmanaged_clocks: [
    { name: "ext_io_div4" }
    { name: "ext_main" }
    { name: "ext_aon" }
  ]

  unmanaged_resets: [
    { name: "ext_rst_io_div4" }
    { name: "ext_rst_main" }
    { name: "ext_rst_aon" }
  ]

  // This is the clock data structure of the design.
  // The hier path refers to the clock reference path (struct / port)
  //   - The top/ext desgination follows the same scheme as inter-module
  // The src key indicates the raw clock sources in the design
  // The groups key indicates the various clock groupings in the design
  clocks: {

    hier_paths: {
      top: "clkmgr_aon_clocks.", // top level is a struct
      ext: "",                   // ext is a port of the clock name
      lpg: "clkmgr_aon_cg_en.",  // top level struct for alert lpg reset enables
    },

    // Clock Source attributes
    // name: Name of group.
    // aon:  Whether the clock is free running all the time.
    //       If it is, the clock is not hanlded by clkmgr.
    // freq: Absolute frequency of clk in Hz
    // ref: indicates the clock is used as a reference for measurement.
    srcs: [
      { name: "main", aon: "no",  freq: "100000000" }
      { name: "io",   aon: "no",  freq: "96000000" }
      { name: "usb",  aon: "no",  freq: "48000000" }
      { name: "aon",  aon: "yes", freq: "200000", ref: true}
    ],

    // Derived clock source attributes
    // name: Name of group.
    // aon:  Whether the clock is free running all the time.
    //       If it is, the clock is not hanlded by clkmgr.
    // freq: Absolute frequency of clk in Hz
    // src:  From which clock source is the clock derived
    // div:  Ratio between derived clock and source clock
    derived_srcs: [
      { name: "io_div2", aon: "no", div: 2, src: "io", freq: "48000000" }
      { name: "io_div4", aon: "no", div: 4, src: "io", freq: "24000000" }
    ],

    // Clock Group attributes
    // name: name of group.
    //
    // src: The hierarchical source of the clock
    // "ext"  - clock is supplied from a port of the top module
    // "top"  - clock is supplied from a net inside the top module
    //
    // sw_cg: whether software is allowed to gate the clock
    // "no"   - software is not allowed to gate clocks
    // "yes"  - software is allowed to gate clocks
    // "hint" - software can provide a hint, and hw controls the rest
    //
    // unique: whether each module in the group can be separately gated
    //         if sw_cg is "no", this field has no meaning
    // "yes"  - each clock is individually controlled
    // "no"   - the group is controlled as one single unit
    //
    // The powerup and proc groups are unique.
    // The powerup group of clocks do not feed through the clock
    // controller as they manage clock controller behavior
    // The proc group is not peripheral, and directly hardwired

    groups: [
      // the powerup group is used exclusively by clk/pwr/rstmgr/pinmux
      { name: "ast",     src:"ext", sw_cg: "no"                   }
      { name: "powerup", src:"top", sw_cg: "no"                   }
      { name: "trans",   src:"top", sw_cg: "hint", unique: "yes", }
      { name: "infra",   src:"top", sw_cg: "no",                  }
      { name: "secure",  src:"top", sw_cg: "yes"                   }
      { name: "peri",    src:"top", sw_cg: "yes",  unique: "no"   }
    ],
  },

  // This is the reset data structure of the design.
  // The hier path refers to the reset reference path (struct / port)
  //   - The top/ext desgination follows the same scheme as inter-module
  // The node key represents all the known resets in the design
  resets: {
    // Discrete OpenTitan does not need to wait for external resets
    wait_for_external_reset: false,

    hier_paths: {
      top: "rstmgr_aon_resets.", // top level is a struct
      ext: "",                   // ext is a port of the clock name
      lpg: "rstmgr_aon_rst_en.", // top level struct for alert lpg reset enables
    },

    // Reset node attributes
    // name: name of reset.
    //
    // gen: whether the reset is generated
    // true: it is a generated reset inside rstmgr
    // false: it is a hardwired design reset inside rstmgr (roots and por)
    // For non-generated resets, the parent / domain definitions have no meaning.
    //
    // type: the reset type [ext, top]
    // ext: the reset is coming in from the ports, external to pwc
    // int: the reset is only used inside rstmgr
    // top: the reset is output from rstmgr to top level struct
    //
    // parent: The parent reset
    // If type is "ext", there is no root, since it is external
    //
    // domains: The power domains of a particular reset
    // This is a list of the supported power domains.
    // Valid values are Aon and (power domain)0 ~ (power domain)1.
    // If no value is supplied, the default is specified by the power configuration.
    //
    // clk:  related clock domain for synchronous release
    // If type is "por", there is not related clock, since it is
    // likely external or generated from a voltage comparator
    //
    nodes: [
      { name: "por_aon",        gen: false, type: "top",                    clock: "aon"     }
      { name: "lc_src",         gen: false, type: "int",                    clock: "io_div4" }
      { name: "sys_src",        gen: false, type: "int",                    clock: "io_div4" }
      { name: "por",            gen: true,  type: "top", parent: "por_aon", clock: "main"    }
      { name: "por_io",         gen: true,  type: "top", parent: "por_aon", clock: "io"      }
      { name: "por_io_div2",    gen: true , type: "top", parent: "por_aon", clock: "io_div2" }
      { name: "por_io_div4",    gen: true , type: "top", parent: "por_aon", clock: "io_div4" }
      { name: "por_usb",        gen: true , type: "top", parent: "por_aon", clock: "usb" }
      { name: "lc",             gen: true,  type: "top", parent: "lc_src",  clock: "main"    }
      { name: "lc_aon",         gen: true,  type: "top", parent: "lc_src",  clock: "aon"     }
      { name: "lc_io",          gen: true,  type: "top", parent: "lc_src",  clock: "io"      }
      { name: "lc_io_div2",     gen: true,  type: "top", parent: "lc_src",  clock: "io_div2" }
      { name: "lc_io_div4",     gen: true,  type: "top", parent: "lc_src",  clock: "io_div4" }
      { name: "lc_usb",         gen: true,  type: "top", parent: "lc_src",  clock: "usb"     }
      { name: "sys",            gen: true,  type: "top", parent: "sys_src", clock: "main", sw: true }
    ]
  }

  // Number of cores: used in rv_plic and timer
  num_cores: "1",

  // Any module with interrupts that doesn't specify plic
  // will have its interrupts sent here
  default_plic: "rv_plic_pwc"

  // `addr_spaces` names the distinct address spaces present in the device.
  // All hosts in the same address space share the same base addresses for
  // all peripherals, though not every peripheral will be accessible to every
  // host in that address space--Access privileges are separate from addresses.
  addr_spaces: [
    { name: "hart"
      desc: "The main address space, shared between the CPU and DM"
      subspaces: [
        { name: "mpwc",
          desc: '''
                MMIO region excludes any memory that is separate from the module configuration
                space, i.e. ROM, main SRAM, and mbx SRAM are excluded but retention SRAM or
                spi_device are included.
                '''
          nodes: [
            "gpio",
            "rv_timer",
            "aon_timer_aon",
            "sram_ctrl_ret_aon",
            "rv_plic_pwc",
            "sram_ctrl_main.regs",
            "sram_ctrl_mbox.regs",
            "dma",
            "mbx0.core",
            "mbx1.core",
            "mbx2.core",
            "mbx3.core",
            "mbx4.core",
            "mbx5.core",
            "rv_core_ibex_pwc"
          ],
        },
      ]
    }
    { name: "soc_mbx", desc: "SoC address space for mailbox access"},
    { name: "soc_dbg", desc: "SoC address space for debug module interfaces"},
  ]

  // `module` defines the peripherals.
  // Details are coming from each modules' config file `ip.hjson`
  // TODO: Define parameter here
  // attr: There are a few types of modules supported
     //   normal(default): Normal, non-templated modules that will be instantiated
     //   templated:   These modules are templated and must be run through topgen
     //   ipgen:       These modules are the same as templated but use the new ipgen flow
     //   reggen_top:  These modules are not templated, but need to have reggen run
     //                because they live exclusively in hw/top_* instead of hw/ip_*.
     //                These modules are also instantiated in the top level.
     //   reggen_only: Similar to reggen_top, but are not instantiated in the top level.
  module: [
    { name: "gpio",
      type: "gpio_pwc",
      template_type: "gpio",
      clock_srcs: {clk_i: "ext_io_div4"},
      clock_group: "peri",
      reset_connections: {rst_ni: "ext_rst_io_div4"},
      base_addr: {
        hart: "0x30000000",
      },
      param_decl: {
        GpioAsHwStrapsEn: "0",
        GpioAsyncOn: "1"
      },
      attr: "ipgen",
      outgoing_alert: "pwc"
      racl_mapping:  '../../top_darjeeling/data/rivos-racl/pwc-star-mappings/isolate_alert_test_mapping.hjson'
    },
    { name: "rv_timer",
      type: "rv_timer",
      clock_srcs: {clk_i: "ext_io_div4"},
      reset_connections: {rst_ni: "ext_rst_io_div4"},
      base_addr: {
        hart: "0x30100000",
      },
      outgoing_alert: "pwc"
      racl_mapping:  '../../top_darjeeling/data/rivos-racl/pwc-star-mappings/isolate_alert_test_mapping.hjson'
    },
    { name: "aon_timer_aon",
      type: "aon_timer",
      clock_srcs: {clk_i: "ext_io_div4", clk_aon_i: "ext_aon"},
      reset_connections: {rst_ni: "ext_rst_io_div4", rst_aon_ni: "ext_rst_aon"},
      domain: ["0"],
      base_addr: {
        hart: "0x30470000",
      },
      outgoing_alert: "pwc"
      racl_mapping:  '../../top_darjeeling/data/rivos-racl/pwc-star-mappings/isolate_alert_test_mapping.hjson'
    },
    { name: "pwc_soc_proxy",
      type: "pwc_soc_proxy",
      clock_srcs: {clk_i: "ext_main"},
      reset_connections: {
        rst_ni: {
          name: "ext_rst_main",
          domain: "0",
        },
      },
      domain: ["0"],
      base_addrs: {
        ctn:  {hart: "0x40000000"},
      },
      attr: "reggen_top",
      memory: {
        ctn: {
          label: "ctn",
          swaccess: "rw",
          data_intg_passthru: "true",
          exec: "True",
          byte_write: "True",
          size: "0x80000000",
        }
      }
      outgoing_alert: "pwc"
    },
    { name: "sram_ctrl_ret_aon",
      type: "sram_ctrl",
      clock_srcs: {clk_i: "ext_io_div4", clk_otp_i: "ext_io_div4"},
      clock_group: "infra",
      reset_connections: {rst_ni: "ext_rst_io_div4", rst_otp_ni: "ext_rst_io_div4"}
      domain: ["0"],
      param_decl: {
        InstrExec: "0",
        InstSize: 4096,
        FlopRamOutput: 1,
        EccCorrection: 1,
        Outstanding: 6
      }
      base_addrs: {
        regs: {hart: "0x30500000"},
        ram:  {hart: "0x30600000"},
      },
      // Memory regions must be associated with a dedicated
      // TL-UL device interface.
      memory: {
        ram: {
          label:    "ram_ret_aon",
          swaccess:   "rw",
          data_intg_passthru: "true",
          exec:       "True",
          byte_write: "True",
          size:     "0x1000"
        }
      }
      outgoing_alert: "pwc"
      racl_mappings: {
        regs: '../../top_darjeeling/data/rivos-racl/pwc-star-mappings/isolate_alert_test_mapping.hjson'
      }
    },
    { name: "rv_dm",
      type: "rv_dm",
      clock_srcs: {clk_i: "ext_main", clk_lc_i: "ext_main"},
      reset_connections: {rst_ni: "ext_rst_main", rst_lc_ni: "ext_rst_main"},
      // Note that this module also contains a bus host.
      base_addrs: {
        mem:  {hart: "0x00040000"},
        regs: {hart: "0x21200000"},
        dbg:  {soc_dbg: "0x00000000"},
      },
      param_decl: {
        // NOTE THAT THIS IS A FEATURE FOR TEST CHIPS ONLY TO MITIGATE
        // THE RISK OF A BROKEN OTP MACRO. THIS WILL BE DISABLED FOR
        // PRODUCTION DEVICES.
        SecVolatileRawUnlockEn: "top_pkg::SecVolatileRawUnlockEn",
        // Use TL-UL based DMI
        UseDmiInterface: "1"
      },
      generate_dif: "False"
      outgoing_alert: "pwc"
      racl_mappings:  {
        regs: '../../top_darjeeling/data/rivos-racl/pwc-star-mappings/isolate_alert_test_mapping.hjson'
      }
    },
    { name: "rv_plic_pwc",
      type: "rv_plic_pwc",
      template_type: "rv_plic",
      ipgen_params: {
        racl_support: true
      }
      clock_srcs: {clk_i: "ext_main"},
      clock_group: "secure",
      reset_connections: {rst_ni: "ext_rst_main"},
      base_addr: {
        hart: "0x28000000",
      },
      attr: "ipgen",
      outgoing_alert: "pwc"
      incoming_interrupt: [
        "pwc_external_irq_cfg.hjson"
      ]
      racl_mapping:  '../../top_darjeeling/data/rivos-racl/pwc-star-mappings/isolate_alert_test_mapping.hjson'
      targets: ["rv_core_ibex_pwc"]
    },
    { name: "sram_ctrl_main",
      type: "sram_ctrl",
      clock_srcs: {clk_i: "ext_main", clk_otp_i: "ext_io_div4"},
      clock_group: "infra",
      reset_connections: {rst_ni: "ext_rst_main", rst_otp_ni: "ext_rst_io_div4"},
      // Note that while it might be useful to allow execution from SRAM for early testing, it can
      // later be permanently disabled using the EN_SRAM_IFETCH switch in OTP.
      param_decl: {
        InstrExec: "1",
        InstSize: 32768,
        NumRamInst: 2
        FlopRamOutput: 1,
        EccCorrection: 1,
        FlopWdataScramble: 1,
        FlopReadAddrScramble: 1,
        Outstanding: 6
      }
      base_addrs: {
        regs: {hart: "0x211c0000"},
        ram:  {hart: "0x10000000"},
      },
      // Memory regions must be associated with a dedicated
      // TL-UL device interface.
      memory: {
        ram: {
          label:      "ram_main",
          swaccess:   "rw",
          data_intg_passthru: "true",
          exec:       "True",
          byte_write: "True",
          size:       "0x10000"
        }
      }
      outgoing_alert: "pwc"
      racl_mappings: {
        regs: '../../top_darjeeling/data/rivos-racl/pwc-star-mappings/isolate_alert_test_mapping.hjson'
      }
    },
    { name: "sram_ctrl_mbox",
      type: "sram_ctrl",
      clock_srcs: {clk_i: "ext_main", clk_otp_i: "ext_io_div4"},
      clock_group: "infra",
      reset_connections: {rst_ni: "ext_rst_main", rst_otp_ni: "ext_rst_io_div4"},
      param_decl: {
        InstrExec: "0",
        InstSize: 4096,
        FlopRamOutput: 1,
        EccCorrection: 1,
        FlopWdataScramble: 1,
        FlopReadAddrScramble: 1,
        Outstanding: 6
      }
      base_addrs: {
        regs: {hart: "0x211d0000"},
        ram:  {hart: "0x11000000"},
      },
      // Memory regions must be associated with a dedicated
      // TL-UL device interface.
      memory: {
        ram: {
          label:    "ram_mbox",
          swaccess:   "rw",
          data_intg_passthru: "true",
          exec:       "False",
          byte_write: "True",
          size:     "0x1000"
        }
      }
      outgoing_alert: "pwc"
      racl_mappings: {
        regs: '../../top_darjeeling/data/rivos-racl/pwc-star-mappings/isolate_alert_test_mapping.hjson'
      }
    },
    { name: "dma",
      type: "dma",
      clock_srcs: {clk_i: "ext_main"}
      clock_group: "infra",
      reset_connections: {rst_ni: "ext_rst_main"},
      base_addr: {hart: "0x22010000"},
      outgoing_alert: "pwc"
      racl_mapping:  '../../top_darjeeling/data/rivos-racl/pwc-star-mappings/isolate_alert_test_mapping.hjson'
    },
    { name: "mbx0",
      type: "mbx",
      clock_srcs: {clk_i: "ext_main"}
      clock_group: "infra",
      reset_connections: {rst_ni: "ext_rst_main"},
      base_addrs: {
        core: {hart: "0x22000000"},
        soc:  {soc_mbx: "0x01475000"},
      },
      outgoing_alert: "pwc"
      racl_mappings: {
        core: '../../top_darjeeling/data/rivos-racl/pwc-star-mappings/isolate_alert_test_mapping.hjson'
        soc: '../../top_darjeeling/data/rivos-racl/pwc-star-mappings/mbx_pwc_private_mapping.hjson'
      }
    },
    { name: "mbx1",
      type: "mbx",
      clock_srcs: {clk_i: "ext_main"}
      clock_group: "infra",
      reset_connections: {rst_ni: "ext_rst_main"},
      base_addrs: {
        core: {hart: "0x22000100"},
        soc:  {soc_mbx: "0x01475100"},
      },
      outgoing_alert: "pwc"
      racl_mappings: {
        core: '../../top_darjeeling/data/rivos-racl/pwc-star-mappings/isolate_alert_test_mapping.hjson'
        soc: '../../top_darjeeling/data/rivos-racl/pwc-star-mappings/mbx_pwc_private_mapping.hjson'
      }
    },
    { name: "mbx2",
      type: "mbx",
      clock_srcs: {clk_i: "ext_main"}
      clock_group: "infra",
      reset_connections: {rst_ni: "ext_rst_main"},
      base_addrs: {
        core: {hart: "0x22000200"},
        soc:  {soc_mbx: "0x01475200"},
      },
      outgoing_alert: "pwc"
      racl_mappings: {
        core: '../../top_darjeeling/data/rivos-racl/pwc-star-mappings/isolate_alert_test_mapping.hjson'
        soc: '../../top_darjeeling/data/rivos-racl/pwc-star-mappings/mbx_pwc_private_mapping.hjson'
      }
    },
    { name: "mbx3",
      type: "mbx",
      clock_srcs: {clk_i: "ext_main"}
      clock_group: "infra",
      reset_connections: {rst_ni: "ext_rst_main"},
      base_addrs: {
        core: {hart: "0x22000300"},
        soc:  {soc_mbx: "0x01475300"},
      },
      outgoing_alert: "pwc"
      racl_mappings: {
        core: '../../top_darjeeling/data/rivos-racl/pwc-star-mappings/isolate_alert_test_mapping.hjson'
        soc: '../../top_darjeeling/data/rivos-racl/pwc-star-mappings/mbx_rot_private_mapping.hjson'
      }
    },
    { name: "mbx4",
      type: "mbx",
      clock_srcs: {clk_i: "ext_main"}
      clock_group: "infra",
      reset_connections: {rst_ni: "ext_rst_main"},
      base_addrs: {
        core: {hart: "0x22000400"},
        soc:  {soc_mbx: "0x01475400"},
      },
      outgoing_alert: "pwc"
      racl_mappings: {
        core: '../../top_darjeeling/data/rivos-racl/pwc-star-mappings/isolate_alert_test_mapping.hjson'
        soc: '../../top_darjeeling/data/rivos-racl/pwc-star-mappings/mbx_mio_private_mapping.hjson'
      }
    },
    { name: "mbx5",
      type: "mbx",
      clock_srcs: {clk_i: "ext_main"}
      clock_group: "infra",
      reset_connections: {rst_ni: "ext_rst_main"},
      base_addrs: {
        core: {hart: "0x22000500"},
        soc:  {soc_mbx: "0x01475500"},
      },
      outgoing_alert: "pwc"
      racl_mappings: {
        core: '../../top_darjeeling/data/rivos-racl/pwc-star-mappings/isolate_alert_test_mapping.hjson'
        soc: '../../top_darjeeling/data/rivos-racl/pwc-star-mappings/mbx_duc_private_mapping.hjson'
      }
    },
    { name: "mbx_pcie0",
      type: "mbx",
      clock_srcs: {clk_i: "ext_main"}
      clock_group: "infra",
      reset_connections: {rst_ni: "ext_rst_main"},
      base_addrs: {
        core: {hart: "0x22040000"},
        soc:  {soc_mbx: "0x01470100"},
      },
      outgoing_alert: "pwc"
      racl_mappings: {
        core: '../../top_darjeeling/data/rivos-racl/pwc-star-mappings/isolate_alert_test_mapping.hjson'
        soc: '../../top_darjeeling/data/rivos-racl/pwc-star-mappings/mbx_all_rd_wr_mapping.hjson'
      }
    },
    { name: "racl_ctrl_pwc",
      type: "racl_ctrl_pwc",
      template_type: "racl_ctrl",
      clock_srcs: {clk_i: "ext_main"}
      clock_group: "infra",
      reset_connections: {rst_ni: "ext_rst_main"},
      base_addr: {
        soc_mbx: "0x01471f00",
      },
      attr: "ipgen",
      ipgen_params: {
        racl_group: "pwc",
        use_rivos_config: true,
      },
      outgoing_alert: "pwc"
      outgoing_interrupt: "pwc"
    },
    { name: "ac_range_check_pwc",
      type: "ac_range_check_pwc",
      template_type: "ac_range_check",
      clock_srcs: {clk_i: "ext_main"},
      clock_group: "secure",
      reset_connections: {rst_ni: "ext_rst_main"},
      base_addr: {
        soc_mbx: "0x01474000"
      },
      param_decl: {
        RangeCheckErrorRsp: 0
      }
      ipgen_params: {
        num_ranges: 32
      }
      attr: "ipgen",
      outgoing_alert: "pwc"
      outgoing_interrupt: "pwc"
      racl_mapping: '../../top_darjeeling/data/rivos-racl/pwc-star-mappings/mbx_rot_private_mapping.hjson'
    },
    { name: "rv_core_ibex_pwc",
      type: "rv_core_ibex_pwc",
      template_type: "rv_core_ibex",
      attr: "ipgen",
      ipgen_params: {
        num_regions: 2
        sim_window_address: 0x440
        racl_support: true
      }
      param_decl: {PMPEnable: "1",
                   PMPGranularity: "0",
                   PMPNumRegions: "16",
                   MHPMCounterNum: "10",
                   MHPMCounterWidth: "32",
                   PMPRstCfg: "ibex_pmp_reset_pkg::PwcPmpCfgRst",
                   PMPRstAddr: "ibex_pmp_reset_pkg::PwcPmpAddrRst",
                   PMPRstMsecCfg: "ibex_pmp_reset_pkg::PwcPmpMseccfgRst",
                   RV32E: "0",
                   RV32M: "ibex_pkg::RV32MSingleCycle",
                   RV32B: "ibex_pkg::RV32BOTEarlGrey",
                   RegFile: "ibex_pkg::RegFileFF",
                   BranchTargetALU: "1",
                   WritebackStage: "1",
                   ICache: "1",
                   ICacheECC: "1",
                   ICacheScramble: "1",
                   BranchPredictor: "0",
                   DbgTriggerEn: "1",
                   DbgHwBreakNum: "4",
                   SecureIbex: "1",
                   DmBaseAddr: "tl_pwc_main_pkg::ADDR_SPACE_RV_DM__MEM",
                   DmAddrMask: "tl_pwc_main_pkg::ADDR_MASK_RV_DM__MEM",
                   DmHaltAddr: "tl_pwc_main_pkg::ADDR_SPACE_RV_DM__MEM + dm::HaltAddress[31:0]",
                   DmExceptionAddr: "tl_pwc_main_pkg::ADDR_SPACE_RV_DM__MEM + dm::ExceptionAddress[31:0]",
                   PipeLine: "1",
                   InstructionPipeline: "1",
                  },
      clock_srcs: {
        clk_i: "ext_main",
        clk_edn_i: "ext_main",
        clk_esc_i: {
          clock: "ext_io_div4",
          group: "secure",
        }
        clk_otp_i: {
          clock: "ext_io_div4",
          group: "secure",
        }
      },
      clock_group: "infra",
      reset_connections: {rst_ni: "ext_rst_main",
                          rst_edn_ni: "ext_rst_main",
                          rst_esc_ni: "ext_rst_io_div4",
                          rst_otp_ni: "ext_rst_io_div4"},
      base_addr: {
        hart: "0x211f0000",
      },
      outgoing_alert: "pwc"
      racl_mappings: {
        cfg: '../../top_darjeeling/data/rivos-racl/pwc-star-mappings/isolate_alert_test_mapping.hjson'
      }
    },
  ]

  // The port data structure is not something that should be used liberally.
  // It is used specifically to assign special attributes to specific ports.
  // For example, this allows us to designate a port as part of inter-module
  // connections.
  port: [
    {
    },
  ]

  // Inter-module Connection.
  // format:
  //    requester: [ resp1, resp2, ... ],
  //
  //  the field and value should be module_inst.port_name
  //  e.g flash_ctrl0.flash: [flash_phy0.flash_ctrl]
  inter_module: {
    'connect': {
      'aon_timer_aon.nmi_wdog_timer_bark' : ['rv_core_ibex_pwc.nmi_wdog']

      // DMA LSIO triggers
      'dma.lsio_trigger'        : ['pwc_soc_proxy.dma_lsio_trigger'],


      // rv_plic connections
      'rv_plic_pwc.msip' : ['rv_core_ibex_pwc.irq_software'],
      'rv_plic_pwc.irq'  : ['rv_core_ibex_pwc.irq_external'],

      // rv_dm connections
      'rv_dm.debug_req': ['rv_core_ibex_pwc.debug_req'],

      pwc_soc_proxy.lc_hw_debug_en' : ['rv_dm.lc_hw_debug_en',
                                       'sram_ctrl_ret_aon.lc_hw_debug_en',
                                       'sram_ctrl_mbox.lc_hw_debug_en',
                                       'sram_ctrl_main.lc_hw_debug_en']
      pwc_soc_proxy.lc_escalate_en' : ['rv_dm.lc_escalate_en',
                                       'sram_ctrl_ret_aon.lc_escalate_en',
                                       'sram_ctrl_mbox.lc_escalate_en',
                                       'sram_ctrl_main.lc_escalate_en',
                                       'aon_timer_aon.lc_escalate_en']
      'sram_ctrl_main.otp_en_sram_ifetch' : ['pwc_soc_proxy.mubi8_true']

      // SOC Proxy TLUL Muxing
      'pwc_soc_proxy.dma_tl_h2d' : ['dma.ctn_tl_h2d']
      'pwc_soc_proxy.dma_tl_d2h' : ['dma.ctn_tl_d2h']

      'pwc_soc_proxy.muxed_tl_h2d' : ['ac_range_check_pwc.ctn_tl_h2d']
      'pwc_soc_proxy.muxed_tl_d2h' : ['ac_range_check_pwc.ctn_tl_d2h']

      'ac_range_check_pwc.ctn_filtered_tl_h2d' : ['pwc_soc_proxy.ac_range_tl_h2d'],
      'ac_range_check_pwc.ctn_filtered_tl_d2h' : ['pwc_soc_proxy.ac_range_tl_d2h'],
    }

    // top is to connect to top net/struct.
    // It defines the signal in the top and connect from the module,
    // use of the signal is up to top template
    'top': [
        // dedicated timer interrupt
        'rv_core_ibex_pwc.irq_timer',

        // hardwired connections
        'rv_core_ibex_pwc.hart_id',

        // Unconditionally disable the late debug feature and enable early debug
        'rv_dm.otp_dis_rv_dm_late_debug'
    ],

    // ext is to create port in the top.
    'external': {
        'dma.sys'                           : 'dma_sys',
        'pwc_mbx.tl_pwc_mbx'                : 'mbx_tl',
        'rv_dm.next_dm_addr'                : 'rv_dm_next_dm_addr',
        'rv_dm.dbg_tl_d'                    : 'rv_dm_dbg',
        'rv_core_ibex_pwc.fpga_info'        : 'fpga_info'
        'rv_core_ibex_pwc.boot_addr'        : 'rv_boot_addr'
        'rv_core_ibex_pwc.pwrmgr_cpu_en'    : 'rv_pwrmgr_cpu_en'
        'rv_core_ibex_pwc.lc_cpu_en'        : 'rv_cpu_en',
        'rv_core_ibex_pwc.esc_rx'           : 'rv_core_esc_rx'
        'rv_core_ibex_pwc.esc_tx'           : 'rv_core_esc_tx'
        'pwc_soc_proxy.lc_hw_debug_en_ext'  : 'lc_hw_debug_en_ext',
        'pwc_soc_proxy.lc_escalate_en_ext'  : 'lc_escalate_en_ext',
        'pwc_soc_proxy.soc_lsio_trigger'    : 'soc_lsio_trigger',
        'pwc_soc_proxy.misc_tl_h2d'         : 'ctn_misc_tl_h2d',
        'pwc_soc_proxy.misc_tl_d2h'         : 'ctn_misc_tl_d2h',
        'pwc_soc_proxy.ctn_tl_h2d'          : 'ctn_tl_h2d',
        'pwc_soc_proxy.ctn_tl_d2h'          : 'ctn_tl_d2h',
        'pwc_soc_proxy.integrator_id'       : 'integrator_id',
        'rv_dm.lc_check_byp_en'             : 'lc_check_byp_en',
        'rv_dm.strap_en       '             : 'rv_dm_strap_en',
        'rv_dm.strap_en_override'           : 'rv_dm_strap_en_override',
        'sram_ctrl_ret_aon.cfg'             : 'sram_ctrl_ret_aon_ram_1p_cfg',
        'sram_ctrl_ret_aon.cfg_rsp'         : 'sram_ctrl_ret_aon_ram_1p_cfg_rsp',
        'sram_ctrl_main.cfg'                : 'sram_ctrl_main_ram_1p_cfg',
        'sram_ctrl_main.cfg_rsp'            : 'sram_ctrl_main_ram_1p_cfg_rsp',
        'sram_ctrl_mbox.cfg'                : 'sram_ctrl_mbox_ram_1p_cfg',
        'sram_ctrl_mbox.cfg_rsp'            : 'sram_ctrl_mbox_ram_1p_cfg_rsp',
        'racl_ctrl_pwc.racl_policies'       : 'racl_policies',
        'racl_ctrl_pwc.racl_error_external' : 'racl_error',
        'ac_range_check_pwc.range_check_overwrite' : 'ac_range_check_overwrite',
        'aon_timer_aon.aon_timer_rst_req'   : 'aon_timer_rst_req'
    },
  },

  // Crossbars: having a top level crossbar
  // This version assumes all crossbars are instantiated at the top.
  // Assume xbar.hjson is located in the same directory of top.hjson
  xbar: [
    { name: "pwc_main",
      clock_srcs: {clk_main_i: "ext_main",
                   clk_fixed_i: "ext_io_div4"},
      clock_group: "infra",
      reset: "ext_rst_main",
      reset_connections: {rst_main_ni: "ext_rst_main",
                          rst_fixed_ni: "ext_rst_io_div4"}
    },
    { name: "pwc_peri",
      clock_srcs: {clk_peri_i: "ext_io_div4", },
      clock_group: "infra",
      reset: "ext_rst_io_div4",
      reset_connections: {rst_peri_ni: "ext_rst_io_div4"},
    },
    { name: "pwc_mbx",
      clock_srcs: {clk_mbx_i: "ext_main"},
      clock_group: "infra",
      reset: "ext_rst_main",
      reset_connections: {rst_mbx_ni: "ext_rst_main"},
    },
  ],

  // ===== PINMUX & PINOUT ======================================================

  pinout: {
    banks: ['VIO'],
    pads: [
    ]
  }

  pinmux: {
    signals: [
    ],

    num_wkup_detect: 8
    wkup_cnt_width:  8
    // Disable USB wakeup and hardware strap sampling for integrated OpenTitan
    enable_usb_wakeup: false
    enable_strap_sampling: false
  }
  targets: [
  ]
}
