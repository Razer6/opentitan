// Copyright lowRISC contributors (OpenTitan project).
// Licensed under the Apache License, Version 2.0, see LICENSE for details.
// SPDX-License-Identifier: Apache-2.0
//
// ------------------- W A R N I N G: A U T O - G E N E R A T E D   C O D E !! -------------------//
// PLEASE DO NOT HAND-EDIT THIS FILE. IT HAS BEEN AUTO-GENERATED WITH THE FOLLOWING COMMAND:
// util/topgen.py -t hw/top_darjeeling/data/top_darjeeling.hjson \
//                -o hw/top_darjeeling/
{
  seed:
  {
    topgen_seed:
    {
      seed_mode: testing
      value: 54333785388384718741805333876851324744086233326576410510444272798345081543471
    }
    lc_ctrl_seed:
    {
      seed_mode: testing
      value: 112993084956605421905698540113828573267222507933600967535087940626766958652087
    }
    otp_img_seed:
    {
      seed_mode: testing
      value: 27979703506148085132361254668065047751677209319772630603289834031211820975395
    }
  }
  module:
  [
    {
      name: otp_ctrl
      type: otp_ctrl
      base_addrs:
      {
        core:
        {
          hart: 0x30130000
        }
      }
      memory: {}
      param_list:
      [
        {
          name: RndCnstLfsrSeed
          desc: Compile-time random bits for initial LFSR seed
          type: otp_ctrl_top_specific_pkg::lfsr_seed_t
          randcount: 40
          randtype: data
          name_top: RndCnstOtpCtrlLfsrSeed
          default: 0xc6f3e6f873
          randwidth: 40
        }
        {
          name: RndCnstLfsrPerm
          desc: Compile-time random permutation for LFSR output
          type: otp_ctrl_top_specific_pkg::lfsr_perm_t
          randcount: 40
          randtype: perm
          name_top: RndCnstOtpCtrlLfsrPerm
          default: 0x16664910b0a358101b40d3130ce4463dd89f81c49e5e421a5251d82959e1
          randwidth: 240
        }
        {
          name: RndCnstScrmblKeyInit
          desc: Compile-time random permutation for scrambling key/nonce register reset value
          type: otp_ctrl_top_specific_pkg::scrmbl_key_init_t
          randcount: 256
          randtype: data
          name_top: RndCnstOtpCtrlScrmblKeyInit
          default: 0xd0edf98ca3085947834f20f8c5743463b15b05dc9332084a51f812a1c9e5d139
          randwidth: 256
        }
        {
          name: RndCnstScrmblKey0
          desc: Compile-time scrambling key
          type: otp_ctrl_top_specific_pkg::key_t
          randcount: 128
          randtype: extdata
          name_top: RndCnstOtpCtrlScrmblKey0
          default: 0xf0e2382e0ee44fa9895f24be4ac18e34
          randwidth: 128
        }
        {
          name: RndCnstScrmblKey1
          desc: Compile-time scrambling key
          type: otp_ctrl_top_specific_pkg::key_t
          randcount: 128
          randtype: extdata
          name_top: RndCnstOtpCtrlScrmblKey1
          default: 0x211e272867d8a5b28f524626bd2392b3
          randwidth: 128
        }
        {
          name: RndCnstScrmblKey2
          desc: Compile-time scrambling key
          type: otp_ctrl_top_specific_pkg::key_t
          randcount: 128
          randtype: extdata
          name_top: RndCnstOtpCtrlScrmblKey2
          default: 0x31e66b4701f65e59af83059cc1ba5509
          randwidth: 128
        }
        {
          name: RndCnstScrmblKey3
          desc: Compile-time scrambling key
          type: otp_ctrl_top_specific_pkg::key_t
          randcount: 128
          randtype: extdata
          name_top: RndCnstOtpCtrlScrmblKey3
          default: 0x12a874275ac734b93bf8f083466ef2f3
          randwidth: 128
        }
        {
          name: RndCnstScrmblKey4
          desc: Compile-time scrambling key
          type: otp_ctrl_top_specific_pkg::key_t
          randcount: 128
          randtype: extdata
          name_top: RndCnstOtpCtrlScrmblKey4
          default: 0xf076e0ba6366de585a1c750847905ca4
          randwidth: 128
        }
        {
          name: RndCnstDigestConst0
          desc: Compile-time digest const
          type: otp_ctrl_top_specific_pkg::digest_const_t
          randcount: 128
          randtype: extdata
          name_top: RndCnstOtpCtrlDigestConst0
          default: 0xa8764c3897d3b202699a4150668f160f
          randwidth: 128
        }
        {
          name: RndCnstDigestConst1
          desc: Compile-time digest const
          type: otp_ctrl_top_specific_pkg::digest_const_t
          randcount: 128
          randtype: extdata
          name_top: RndCnstOtpCtrlDigestConst1
          default: 0xe65ed1a810ca3c846bae953b000abd46
          randwidth: 128
        }
        {
          name: RndCnstDigestIV0
          desc: Compile-time digest initial vector
          type: otp_ctrl_top_specific_pkg::digest_iv_t
          randcount: 64
          randtype: extdata
          name_top: RndCnstOtpCtrlDigestIV0
          default: 0x2d31b460654aea39
          randwidth: 64
        }
        {
          name: RndCnstDigestIV1
          desc: Compile-time digest initial vector
          type: otp_ctrl_top_specific_pkg::digest_iv_t
          randcount: 64
          randtype: extdata
          name_top: RndCnstOtpCtrlDigestIV1
          default: 0xfe81243c9287d208
          randwidth: 64
        }
        {
          name: RndCnstPartInvDefault
          desc: OTP invalid partition default for buffered partitions
          type: logic [163839:0]
          randcount: 163840
          randtype: extdata
          name_top: RndCnstOtpCtrlPartInvDefault
          default:
          [
            {
              size: 704
              items:
              [
                {
                  size: 320
                  inv_default: 537198649743330568046723673202728193106326685176313773708748096931852411214074445109624675237285
                }
                {
                  size: 384
                  inv_default: 3496745244658753459073187228781572085007539322218764545726484915301415044255822991003568768409845418041547340349768
                }
              ]
            }
            {
              size: 384
              items:
              [
                {
                  size: 64
                  inv_default: 0
                }
                {
                  size: 64
                  inv_default: 8803623895717951126
                }
                {
                  size: 256
                  inv_default: 94329640851707705236174009281698748906805576226486076261469603099328103605553
                }
              ]
            }
            {
              size: 384
              items:
              [
                {
                  size: 64
                  inv_default: 0
                }
                {
                  size: 64
                  inv_default: 497467941740258226
                }
                {
                  size: 256
                  inv_default: 19830000025622029573677199637204762658025534707517704692633306816785844362576
                }
              ]
            }
            {
              size: 1024
              items:
              [
                {
                  size: 64
                  inv_default: 0
                }
                {
                  size: 64
                  inv_default: 15563155100447382093
                }
                {
                  size: 256
                  inv_default: 96480450212453159177018096846071164700916456418131765720823327479747856687073
                }
                {
                  size: 256
                  inv_default: 67220341781509999623712039064327034068478221195092240487458626141753473591957
                }
                {
                  size: 256
                  inv_default: 112937609658104557664720235924162363129336311225833316865587187995631593533954
                }
                {
                  size: 128
                  inv_default: 20436423525667573507812865364543471489
                }
              ]
            }
            {
              size: 256
              items:
              [
                {
                  size: 64
                  inv_default: 0
                }
                {
                  size: 64
                  inv_default: 7881896702500903297
                }
                {
                  size: 128
                  inv_default: 144061002521554659338161712592818323021
                }
              ]
            }
            {
              size: 384
              items:
              [
                {
                  size: 64
                  inv_default: 0
                }
                {
                  size: 64
                  inv_default: 6314004083024320026
                }
                {
                  size: 128
                  inv_default: 113334116849525231636942507222723753753
                }
                {
                  size: 128
                  inv_default: 182177191635167705173937616829284258131
                }
              ]
            }
            {
              size: 448
              items:
              [
                {
                  size: 64
                  inv_default: 0
                }
                {
                  size: 64
                  inv_default: 899833317950292790
                }
                {
                  comment: unallocated space
                  size: 32
                  inv_default: 0
                }
                {
                  size: 256
                  inv_default: 28807926661450089350912902427449764760189093586386285279945247574061280326626
                }
                {
                  size: 32
                  inv_default: 0
                }
              ]
            }
            {
              size: 192
              items:
              [
                {
                  size: 64
                  inv_default: 0
                }
                {
                  size: 64
                  inv_default: 6911337809181396458
                }
                {
                  comment: unallocated space
                  size: 48
                  inv_default: 0
                }
                {
                  size: 8
                  inv_default: 105
                }
                {
                  size: 8
                  inv_default: 105
                }
              ]
            }
            {
              size: 384
              items:
              [
                {
                  size: 64
                  inv_default: 0
                }
                {
                  size: 64
                  inv_default: 13022557762012396181
                }
                {
                  size: 256
                  inv_default: 40501398844832094875114408663879061209118058814964110894288788264184189765987
                }
              ]
            }
            {
              size: 33856
              items:
              [
                {
                  size: 64
                  inv_default: 13613404859098530722
                }
                {
                  size: 30720
                  inv_default: 0
                }
                {
                  size: 3072
                  inv_default: 0
                }
              ]
            }
            {
              size: 3136
              items:
              [
                {
                  size: 64
                  inv_default: 8187068425930011275
                }
                {
                  size: 1024
                  inv_default: 0
                }
                {
                  size: 2048
                  inv_default: 0
                }
              ]
            }
            {
              size: 85952
              items:
              [
                {
                  size: 64
                  inv_default: 0
                }
                {
                  size: 64
                  inv_default: 3482940500857016635
                }
                {
                  comment: unallocated space
                  size: 12288
                  inv_default: 0
                }
                {
                  size: 73536
                  inv_default: 0
                }
              ]
            }
            {
              size: 8256
              items:
              [
                {
                  size: 64
                  inv_default: 0
                }
                {
                  size: 8192
                  inv_default: 0
                }
              ]
            }
            {
              size: 1280
              items:
              [
                {
                  size: 64
                  inv_default: 0
                }
                {
                  size: 64
                  inv_default: 9351492217133262506
                }
                {
                  size: 512
                  inv_default: 0
                }
                {
                  size: 32
                  inv_default: 0
                }
                {
                  size: 32
                  inv_default: 0
                }
                {
                  size: 512
                  inv_default: 0
                }
                {
                  size: 32
                  inv_default: 0
                }
                {
                  size: 32
                  inv_default: 0
                }
              ]
            }
            {
              size: 1280
              items:
              [
                {
                  size: 64
                  inv_default: 0
                }
                {
                  size: 64
                  inv_default: 17244459621709600035
                }
                {
                  size: 512
                  inv_default: 0
                }
                {
                  size: 32
                  inv_default: 0
                }
                {
                  size: 32
                  inv_default: 0
                }
                {
                  size: 512
                  inv_default: 0
                }
                {
                  size: 32
                  inv_default: 0
                }
                {
                  size: 32
                  inv_default: 0
                }
              ]
            }
            {
              size: 1280
              items:
              [
                {
                  size: 64
                  inv_default: 0
                }
                {
                  size: 64
                  inv_default: 11795428238417073728
                }
                {
                  size: 512
                  inv_default: 0
                }
                {
                  size: 32
                  inv_default: 0
                }
                {
                  size: 32
                  inv_default: 0
                }
                {
                  size: 512
                  inv_default: 0
                }
                {
                  size: 32
                  inv_default: 0
                }
                {
                  size: 32
                  inv_default: 0
                }
              ]
            }
            {
              size: 1280
              items:
              [
                {
                  size: 64
                  inv_default: 0
                }
                {
                  size: 64
                  inv_default: 15422691379567619171
                }
                {
                  size: 512
                  inv_default: 0
                }
                {
                  size: 32
                  inv_default: 0
                }
                {
                  size: 32
                  inv_default: 0
                }
                {
                  size: 512
                  inv_default: 0
                }
                {
                  size: 32
                  inv_default: 0
                }
                {
                  size: 32
                  inv_default: 0
                }
              ]
            }
            {
              size: 1280
              items:
              [
                {
                  size: 64
                  inv_default: 0
                }
                {
                  size: 64
                  inv_default: 7205140007485333107
                }
                {
                  size: 512
                  inv_default: 0
                }
                {
                  size: 32
                  inv_default: 0
                }
                {
                  size: 32
                  inv_default: 0
                }
                {
                  size: 512
                  inv_default: 0
                }
                {
                  size: 32
                  inv_default: 0
                }
                {
                  size: 32
                  inv_default: 0
                }
              ]
            }
            {
              size: 1280
              items:
              [
                {
                  size: 64
                  inv_default: 0
                }
                {
                  size: 64
                  inv_default: 2505618692864360002
                }
                {
                  size: 512
                  inv_default: 0
                }
                {
                  size: 32
                  inv_default: 0
                }
                {
                  size: 32
                  inv_default: 0
                }
                {
                  size: 512
                  inv_default: 0
                }
                {
                  size: 32
                  inv_default: 0
                }
                {
                  size: 32
                  inv_default: 0
                }
              ]
            }
            {
              size: 1280
              items:
              [
                {
                  size: 64
                  inv_default: 0
                }
                {
                  size: 64
                  inv_default: 1525114536255331369
                }
                {
                  size: 512
                  inv_default: 0
                }
                {
                  size: 32
                  inv_default: 0
                }
                {
                  size: 32
                  inv_default: 0
                }
                {
                  size: 512
                  inv_default: 0
                }
                {
                  size: 32
                  inv_default: 0
                }
                {
                  size: 32
                  inv_default: 0
                }
              ]
            }
            {
              size: 2752
              items:
              [
                {
                  size: 64
                  inv_default: 0
                }
                {
                  size: 64
                  inv_default: 157542749280826575
                }
                {
                  size: 512
                  inv_default: 0
                }
                {
                  size: 128
                  inv_default: 0
                }
                {
                  size: 256
                  inv_default: 0
                }
                {
                  size: 512
                  inv_default: 0
                }
                {
                  size: 32
                  inv_default: 0
                }
                {
                  size: 32
                  inv_default: 0
                }
                {
                  size: 512
                  inv_default: 0
                }
                {
                  size: 32
                  inv_default: 0
                }
                {
                  size: 32
                  inv_default: 0
                }
                {
                  size: 512
                  inv_default: 0
                }
                {
                  size: 32
                  inv_default: 0
                }
                {
                  size: 32
                  inv_default: 0
                }
              ]
            }
            {
              size: 6400
              items:
              [
                {
                  size: 64
                  inv_default: 0
                }
                {
                  size: 64
                  inv_default: 15710116330355108305
                }
                {
                  size: 128
                  inv_default: 0
                }
                {
                  size: 6144
                  inv_default: 0
                }
              ]
            }
            {
              size: 448
              items:
              [
                {
                  size: 64
                  inv_default: 0
                }
                {
                  size: 128
                  inv_default: 0
                }
                {
                  size: 128
                  inv_default: 0
                }
                {
                  size: 128
                  inv_default: 0
                }
              ]
            }
            {
              size: 7808
              items:
              [
                {
                  size: 64
                  inv_default: 0
                }
                {
                  size: 64
                  inv_default: 11632389595399639639
                }
                {
                  comment: unallocated space
                  size: 32
                  inv_default: 0
                }
                {
                  size: 32
                  inv_default: 0
                }
                {
                  size: 32
                  inv_default: 0
                }
                {
                  size: 32
                  inv_default: 0
                }
                {
                  size: 32
                  inv_default: 0
                }
                {
                  size: 32
                  inv_default: 0
                }
                {
                  size: 32
                  inv_default: 0
                }
                {
                  size: 32
                  inv_default: 0
                }
                {
                  size: 512
                  inv_default: 0
                }
                {
                  size: 128
                  inv_default: 0
                }
                {
                  size: 128
                  inv_default: 0
                }
                {
                  size: 224
                  inv_default: 0
                }
                {
                  size: 6304
                  inv_default: 0
                }
                {
                  size: 32
                  inv_default: 0
                }
                {
                  size: 32
                  inv_default: 0
                }
                {
                  size: 32
                  inv_default: 0
                }
                {
                  size: 32
                  inv_default: 0
                }
              ]
            }
            {
              size: 1536
              items:
              [
                {
                  size: 64
                  inv_default: 0
                }
                {
                  size: 64
                  inv_default: 13228548611043289812
                }
                {
                  comment: unallocated space
                  size: 32
                  inv_default: 0
                }
                {
                  size: 32
                  inv_default: 0
                }
                {
                  size: 32
                  inv_default: 0
                }
                {
                  size: 32
                  inv_default: 0
                }
                {
                  size: 32
                  inv_default: 0
                }
                {
                  size: 32
                  inv_default: 0
                }
                {
                  size: 32
                  inv_default: 0
                }
                {
                  size: 32
                  inv_default: 0
                }
                {
                  size: 32
                  inv_default: 0
                }
                {
                  size: 32
                  inv_default: 1768515945
                }
                {
                  size: 32
                  inv_default: 1768515945
                }
                {
                  size: 32
                  inv_default: 1768515945
                }
                {
                  size: 32
                  inv_default: 0
                }
                {
                  size: 992
                  inv_default: 0
                }
              ]
            }
            {
              size: 576
              items:
              [
                {
                  size: 64
                  inv_default: 0
                }
                {
                  size: 64
                  inv_default: 3896831752066432124
                }
                {
                  size: 448
                  inv_default: 0
                }
              ]
            }
          ]
          randwidth: 163840
        }
      ]
      template_type: otp_ctrl
      otp_mmap:
      {
        otp:
        {
          width: 2
          depth: 10240
          size: 20480
          addr_width: 14
          byte_addr_width: 15
        }
        scrambling:
        {
          key_size: 16
          iv_size: 8
          cnst_size: 16
          keys:
          [
            {
              name: Secret0Key
              value: 320189317542450762109386389465346444852
            }
            {
              name: Secret1Key
              value: 44021086981898178093354400183545467571
            }
            {
              name: Secret2Key
              value: 66328575914558343686655006108878001417
            }
            {
              name: Secret3Key
              value: 24800765673869174505990593035608453875
            }
            {
              name: Secret4Key
              value: 319631968044639741185501772586027080868
            }
          ]
          digests:
          [
            {
              name: CnstyDigest
              iv_value: 3256582331674847801
              cnst_value: 223924540268068115090460007335046616591
            }
            {
              name: SramDataKey
              iv_value: 18338979000204382728
              cnst_value: 306214767274367639117906980600231411014
            }
          ]
          num_keys: 5
          num_digests: 2
        }
        partitions:
        [
          {
            name: VENDOR_TEST
            variant: Unbuffered
            absorb: false
            secret: false
            sw_digest: true
            hw_digest: false
            write_lock: Digest
            read_lock: CSR
            key_sel: NoKey
            integrity: false
            bkout_type: false
            zeroizable: true
            items:
            [
              {
                name: SCRATCH
                size: 56
                isdigest: false
                iszer: false
                ismubi: false
                iskeymgr_creator: false
                iskeymgr_owner: false
                inv_default: 0
                offset: 0
              }
              {
                name: VENDOR_TEST_DIGEST
                size: 8
                offset: 56
                ismubi: false
                isdigest: true
                iszer: false
                inv_default: 3896831752066432124
                iskeymgr_creator: false
                iskeymgr_owner: false
              }
              {
                name: VENDOR_TEST_ZER
                size: 8
                offset: 64
                ismubi: false
                isdigest: false
                iszer: true
                inv_default: 0
                iskeymgr_creator: false
                iskeymgr_owner: false
              }
            ]
            desc:
              '''
              Vendor test partition.
              This is reserved for manufacturing smoke checks. The OTP wrapper
              control logic inside prim_otp is allowed to read/write to this
              region. ECC uncorrectable errors seen on the functional prim_otp
              interface will not lead to an alert for this partition.
              Instead, such errors will be reported as correctable ECC errors.
              '''
            iskeymgr_creator: false
            iskeymgr_owner: false
            size: 72
            offset: 0
          }
          {
            name: CREATOR_SW_CFG
            variant: Unbuffered
            absorb: false
            secret: false
            sw_digest: true
            hw_digest: false
            write_lock: Digest
            read_lock: CSR
            key_sel: NoKey
            integrity: true
            bkout_type: false
            zeroizable: true
            items:
            [
              {
                name: CREATOR_SW_CFG_AST_CFG
                size: 124
                desc:
                  '''
                  AST configuration data. These values get blindly copied to
                  the AST CSRs during ROM execution.
                  '''
                isdigest: false
                iszer: false
                ismubi: false
                iskeymgr_creator: false
                iskeymgr_owner: false
                inv_default: 0
                offset: 72
              }
              {
                name: CREATOR_SW_CFG_AST_INIT_EN
                size: 4
                desc:
                  '''
                  Controls whether or not the CREATOR_SW_CFG_AST_CFG values
                  get copied to the AST CSRs during ROM execution.
                  A value of kMultiBitBool4True enables copying; all other
                  values disable.
                  '''
                isdigest: false
                iszer: false
                ismubi: false
                iskeymgr_creator: false
                iskeymgr_owner: false
                inv_default: 0
                offset: 196
              }
              {
                name: CREATOR_SW_CFG_ROM_SECURE_BOOT_EN
                size: 4
                ismubi: true
                inv_default: 1768515945
                desc:
                  '''
                  Secure boot chicken bit. Secure boot is enabled iff this is
                  set to kMultiBitBool32True. OTBN is not loaded with any code
                  for any other values.
                  '''
                isdigest: false
                iszer: false
                iskeymgr_creator: false
                iskeymgr_owner: false
                offset: 200
              }
              {
                name: CREATOR_SW_CFG_ROM_SIGGEN_EN
                size: 4
                ismubi: true
                inv_default: 1768515945
                desc:
                  '''
                  Signature generation chicken bit. Asset signatures are
                  generated iff both this item and
                  CREATOR_SW_CFG_ROM_SECURE_BOOT_EN are set to
                  kMultiBitBool32True.
                  '''
                isdigest: false
                iszer: false
                iskeymgr_creator: false
                iskeymgr_owner: false
                offset: 204
              }
              {
                name: CREATOR_SW_CFG_ROM_SIGVERIFY_EN
                size: 4
                ismubi: true
                inv_default: 1768515945
                desc:
                  '''
                  Signature verification chicken bit. Asset signatures are
                  verified iff this item, the CREATOR_SW_CFG_ROM_SECURE_BOOT_EN
                  and the CREATOR_SW_CFG_ROM_SIGGEN_EN ones are all set to
                  kMultiBitBool32True.
                  '''
                isdigest: false
                iszer: false
                iskeymgr_creator: false
                iskeymgr_owner: false
                offset: 208
              }
              {
                name: CREATOR_SW_CFG_SIGVERIFY_SPX_EN
                size: 4
                desc:
                  '''
                  Controls whether or not SPHINCS+ signature verification will
                  be executed when the ROM attempts to boot the ROM_EXT.
                  A value of kSigverifySpxDisabledOtp disables SPHINCS+
                  signature verification, while all other values enable it.
                  Note, SPHINCS+ signature verification is always disabled in
                  TEST_UNLOCKED* LC states.
                  '''
                isdigest: false
                iszer: false
                ismubi: false
                iskeymgr_creator: false
                iskeymgr_owner: false
                inv_default: 0
                offset: 212
              }
              {
                name: CREATOR_SW_CFG_RNG_EN
                size: 4
                desc:
                  '''
                  Whether or not to enable use of hardware generated entropy
                  (from the entropy complex via EDN) in the `rnd_uint32`
                  function. A value of kHardenedBoolTrue enables the use of
                  hardware generated entropy, while all other values disable.
                  '''
                isdigest: false
                iszer: false
                ismubi: false
                iskeymgr_creator: false
                iskeymgr_owner: false
                inv_default: 0
                offset: 216
              }
              {
                name: CREATOR_SW_CFG_JITTER_EN
                size: 4
                desc:
                  '''
                  Whether or not to enable clock jitter. A value of
                  kMultiBitBool4False disables, while all other values enable.
                  '''
                isdigest: false
                iszer: false
                ismubi: false
                iskeymgr_creator: false
                iskeymgr_owner: false
                inv_default: 0
                offset: 220
              }
              {
                name: CREATOR_SW_CFG_RET_RAM_RESET_MASK
                size: 4
                desc:
                  '''
                  Reset reason mask used to initialize (by overwriting with
                  random data) retention SRAM during ROM execution. A value of
                  0 only initializes retention SRAM on power-on-resets.See
                  rstmgr RESET_INFO CSR documentation for more details.
                  '''
                isdigest: false
                iszer: false
                ismubi: false
                iskeymgr_creator: false
                iskeymgr_owner: false
                inv_default: 0
                offset: 224
              }
              {
                name: CREATOR_SW_CFG_CPUCTRL
                size: 4
                desc:
                  '''
                  Value to write to the Ibex CPUCTRL CSR during ROM execution.
                  This field controls settings such as ICACHE enablement. See
                  Ibex documentation for more information.
                  '''
                isdigest: false
                iszer: false
                ismubi: false
                iskeymgr_creator: false
                iskeymgr_owner: false
                inv_default: 0
                offset: 228
              }
              {
                name: CREATOR_SW_CFG_RMA_SPIN_EN
                size: 4
                desc:
                  '''
                  Whether or not to enable a busy-wait delay loop in the ROM,
                  when a specific SW strapping configuration is applied during
                  boot, to provide time to trigger an RMA life-cycle transition
                  over JTAG. A value of kHardenedBoolTrue enables, all other
                  values disable.
                  '''
                isdigest: false
                iszer: false
                ismubi: false
                iskeymgr_creator: false
                iskeymgr_owner: false
                inv_default: 0
                offset: 232
              }
              {
                name: CREATOR_SW_CFG_RMA_SPIN_CYCLES
                size: 4
                desc:
                  '''
                  The number of Ibex clock cycles to spin for when waiting for
                  an RMA transition. Used in combination with the
                  CREATOR_SW_CFG_RMA_SPIN_EN field.
                  '''
                isdigest: false
                iszer: false
                ismubi: false
                iskeymgr_creator: false
                iskeymgr_owner: false
                inv_default: 0
                offset: 236
              }
              {
                name: CREATOR_SW_CFG_SRAM_KEY_RENEW_EN
                size: 4
                desc:
                  '''
                  Whether or not the ROM should request SRAM to be re-scrambled
                  with a new key on every boot. kHardenedBoolFalse disables,
                  while all other values enable.
                  '''
                isdigest: false
                iszer: false
                ismubi: false
                iskeymgr_creator: false
                iskeymgr_owner: false
                inv_default: 0
                offset: 240
              }
              {
                name: CREATOR_SW_CFG_DIGEST
                size: 8
                offset: 248
                ismubi: false
                isdigest: true
                iszer: false
                inv_default: 13228548611043289812
                iskeymgr_creator: false
                iskeymgr_owner: false
              }
              {
                name: CREATOR_SW_CFG_ZER
                size: 8
                offset: 256
                ismubi: false
                isdigest: false
                iszer: true
                inv_default: 0
                iskeymgr_creator: false
                iskeymgr_owner: false
              }
            ]
            desc:
              '''
              Software configuration partition.
              This is for device-specific calibration data. For example, clock,
              LDO, RNG.
              '''
            iskeymgr_creator: false
            iskeymgr_owner: false
            size: 192
            offset: 72
          }
          {
            name: OWNER_SW_CFG
            variant: Unbuffered
            absorb: false
            secret: false
            sw_digest: true
            hw_digest: false
            write_lock: Digest
            read_lock: CSR
            key_sel: NoKey
            integrity: true
            bkout_type: false
            zeroizable: true
            items:
            [
              {
                name: OWNER_SW_CFG_ROM_ERROR_REPORTING
                size: 4
                desc:
                  '''
                  The shutdown error reporting verbosity used by the ROM.
                  Should be configured to one of several
                  `shutdown_error_redact_t` values. See
                  `sw/device/silicon_creator/lib/shutdown.h` for more details.
                  '''
                isdigest: false
                iszer: false
                ismubi: false
                iskeymgr_creator: false
                iskeymgr_owner: false
                inv_default: 0
                offset: 264
              }
              {
                name: OWNER_SW_CFG_ROM_BOOTSTRAP_DIS
                size: 4
                desc:
                  '''
                  Whether or not to disable ROM bootstrap mechanism. A value
                  of kHardenedBoolTrue disable bootstrap mechanism in the ROM,
                  while all other values enable it. Note, the provisioning
                  flow should take care when to program this field if it is
                  used by a SKU, as there is no way to get firmware into flash
                  in a PROD LC state if a valid ROM_EXT does not already exist
                  in flash once this value is configured to true.
                  '''
                isdigest: false
                iszer: false
                ismubi: false
                iskeymgr_creator: false
                iskeymgr_owner: false
                inv_default: 0
                offset: 268
              }
              {
                name: OWNER_SW_CFG_ROM_ALERT_CLASS_EN
                size: 4
                desc:
                  '''
                  A four byte packed field, where each byte controls whether
                  or not the ROM enables each alert class (A through D) of the
                  alert_handler. The byte-sized sub-fields are arranged from D
                  to A, MSB to LSB. Each byte should be set to an
                  `alert_enable_t` value accordingly. See the alert_handler
                  documentation for more details.
                  '''
                isdigest: false
                iszer: false
                ismubi: false
                iskeymgr_creator: false
                iskeymgr_owner: false
                inv_default: 0
                offset: 272
              }
              {
                name: OWNER_SW_CFG_ROM_ALERT_ESCALATION
                size: 4
                desc:
                  '''
                  A four byte packed field, where each byte controls the
                  escalation configuration for each alert class (A through D)
                  of the alert_handler configured by the ROM. The byte-sized
                  sub-fields are arranged from D to A, MSB to LSB. Each byte
                  should be set to an `alert_escalate_t` value accordingly.
                  See the alert_handler documentation for more details.
                  '''
                isdigest: false
                iszer: false
                ismubi: false
                iskeymgr_creator: false
                iskeymgr_owner: false
                inv_default: 0
                offset: 276
              }
              {
                name: OWNER_SW_CFG_ROM_ALERT_CLASSIFICATION
                size: 788
                desc:
                  '''
                  The alert classifications (A through D) for each alert
                  source of the alert_handler to be configured by the ROM. The
                  field consists of a contiguous 320-byte block, or 80 32-bit
                  words. The four bytes in each word encode the configuration
                  of a single alert source across four lifecycle states, in
                  order from LSB to MSB: PROD, PROD_END, DEV, and RMA. Each
                  byte should be set to an `alert_class_t` value accordingly.
                  The order of the 197 32-bit words, from LSB to MSB can be
                  found in the DARJEELING_ALERTS list in
                  `hw/top_darjeeling/data/autogen/defs.bzl`.
                  See the alert_handler documentation for more details.
                  '''
                isdigest: false
                iszer: false
                ismubi: false
                iskeymgr_creator: false
                iskeymgr_owner: false
                inv_default: 0
                offset: 280
              }
              {
                name: OWNER_SW_CFG_ROM_LOCAL_ALERT_CLASSIFICATION
                size: 28
                desc:
                  '''
                  Same as the `OWNER_SW_CFG_ROM_ALERT_CLASSIFICATION` field,
                  except these configuration correspond to the local alert
                  sources found in the `DARJEELING_LOC_ALERTS list in
                  `rules/const.bzl`.
                  '''
                isdigest: false
                iszer: false
                ismubi: false
                iskeymgr_creator: false
                iskeymgr_owner: false
                inv_default: 0
                offset: 1068
              }
              {
                name: OWNER_SW_CFG_ROM_ALERT_ACCUM_THRESH
                size: 16
                desc:
                  '''
                  The alert accumulation threshold values for each alert class
                  (A through D) of the alert_handler to be configured by the
                  ROM. This field consists of four 32-bit words encoding the
                  accumulation thresholds for each alert class A through D
                  arranged LSW to MSW. See the alert_handler documentation for
                  more details.
                  '''
                isdigest: false
                iszer: false
                ismubi: false
                iskeymgr_creator: false
                iskeymgr_owner: false
                inv_default: 0
                offset: 1096
              }
              {
                name: OWNER_SW_CFG_ROM_ALERT_TIMEOUT_CYCLES
                size: 16
                desc:
                  '''
                  Same as the `OWNER_SW_CFG_ROM_ALERT_ACCUM_THRESH` field,
                  except each value corresponds to the interrupt timeout
                  configuration of an alert class.
                  '''
                isdigest: false
                iszer: false
                ismubi: false
                iskeymgr_creator: false
                iskeymgr_owner: false
                inv_default: 0
                offset: 1112
              }
              {
                name: OWNER_SW_CFG_ROM_ALERT_PHASE_CYCLES
                size: 64
                desc:
                  '''
                  The alert escalation phase durations, measured in clock
                  cycles, the ROM will configure the four alert phases for
                  each alert class of the alert_handler. This field consists
                  of a contiguous 64-byte block, or an array of four 128-bit
                  fields. Each 128-bit sub-field encodes four 32-bit words that
                  contain the alert phase cycle count configurations for alert
                  escalation phases 0 to 3, from LSW to MSW. Each 128-bit
                  sub-field is contains all configurations for a single alert
                  class, arranged from class A to D, from LS to MS. For
                  example, the cycle durations of each escalation phase in
                  this field should be configured as such, from LSB to MSB:
                  <classA,phase0>...<classA,phase3>...<classD,phase0>...
                  <classD,phase3>. See the alert_handler documentation for
                  more details.
                  '''
                isdigest: false
                iszer: false
                ismubi: false
                iskeymgr_creator: false
                iskeymgr_owner: false
                inv_default: 0
                offset: 1128
              }
              {
                name: OWNER_SW_CFG_ROM_ALERT_DIGEST_PROD
                size: 4
                desc:
                  '''
                  The expected CRC32 digest over all of the alert_handler
                  configurations set up by the ROM for a device operating in
                  the PROD LC state. The ROM reads this field and checks it
                  against a digest it computes over the alert_handler
                  configuration it programmed. This field is expected to be
                  automatically computed by the `otp_alert_digest()` Bazel
                  rule. See the `alert_config_crc32()` function in the
                  SiliconCreator alert_handler driver for more details on what
                  configurations are included in this digest.
                  '''
                isdigest: false
                iszer: false
                ismubi: false
                iskeymgr_creator: false
                iskeymgr_owner: false
                inv_default: 0
                offset: 1192
              }
              {
                name: OWNER_SW_CFG_ROM_ALERT_DIGEST_PROD_END
                size: 4
                desc:
                  '''
                  Same as the `OWNER_SW_CFG_ROM_ALERT_DIGEST_PROD` field,
                  except the expected digest is for chips operating in the
                  PROD_END LC state.
                  '''
                isdigest: false
                iszer: false
                ismubi: false
                iskeymgr_creator: false
                iskeymgr_owner: false
                inv_default: 0
                offset: 1196
              }
              {
                name: OWNER_SW_CFG_ROM_ALERT_DIGEST_DEV
                size: 4
                desc:
                  '''
                  Same as the `OWNER_SW_CFG_ROM_ALERT_DIGEST_PROD` field,
                  except the expected digest is for chips operating in the
                  DEV LC state.
                  '''
                isdigest: false
                iszer: false
                ismubi: false
                iskeymgr_creator: false
                iskeymgr_owner: false
                inv_default: 0
                offset: 1200
              }
              {
                name: OWNER_SW_CFG_ROM_ALERT_DIGEST_RMA
                size: 4
                desc:
                  '''
                  Same as the `OWNER_SW_CFG_ROM_ALERT_DIGEST_PROD` field,
                  except the expected digest is for chips operating in the
                  RMA LC state.
                  '''
                isdigest: false
                iszer: false
                ismubi: false
                iskeymgr_creator: false
                iskeymgr_owner: false
                inv_default: 0
                offset: 1204
              }
              {
                name: OWNER_SW_CFG_ROM_WATCHDOG_BITE_THRESHOLD_CYCLES
                size: 4
                desc: Watchdog timer bite threshold (in cycles) configured by the ROM.
                isdigest: false
                iszer: false
                ismubi: false
                iskeymgr_creator: false
                iskeymgr_owner: false
                inv_default: 0
                offset: 1208
              }
              {
                name: OWNER_SW_CFG_ROM_KEYMGR_OTP_MEAS_EN
                size: 4
                desc:
                  '''
                  Whether or not to configure the attestation SW binding CSRs
                  of the keymgr with the value of the measurement of the OTP
                  CreatorSwCfg, OwnerSwCfg, and secure boot key integrity digest.
                  A value of kHardenedBoolTrue uses the ROM computed OTP
                  measurements.
                  '''
                isdigest: false
                iszer: false
                ismubi: false
                iskeymgr_creator: false
                iskeymgr_owner: false
                inv_default: 0
                offset: 1212
              }
              {
                name: OWNER_SW_CFG_ROM_RSTMGR_INFO_EN
                size: 4
                desc:
                  '''
                  A two byte packed word that indicates the expected rstmgr
                  alert and CPU info dump enable states, configured in the
                  rstmgr's ALERT_INFO_CTRL and CPU_INFO_CTRL CSRs respectively.
                  The expected format of this fields is
                  {0,0,kHardenedBool*,kHardenedBool*}, read MSB to LSB, where
                  the left most kHardenedBool* entry indicates the expected
                  enablement state of the ALERT_INFO_CTRL, and the right most
                  indicates the enablement state of the CPU_INFO_CTRL. Since
                  the ROM expects both to be disabled upon handing over
                  execution control to the ROM_EXT, this entire OTP field
                  **should be left unprovisioned, or set to all 0**.
                  '''
                isdigest: false
                iszer: false
                ismubi: false
                iskeymgr_creator: false
                iskeymgr_owner: false
                inv_default: 0
                offset: 1216
              }
              {
                name: OWNER_SW_CFG_DIGEST
                size: 8
                offset: 1224
                ismubi: false
                isdigest: true
                iszer: false
                inv_default: 11632389595399639639
                iskeymgr_creator: false
                iskeymgr_owner: false
              }
              {
                name: OWNER_SW_CFG_ZER
                size: 8
                offset: 1232
                ismubi: false
                isdigest: false
                iszer: true
                inv_default: 0
                iskeymgr_creator: false
                iskeymgr_owner: false
              }
            ]
            desc:
              '''
              Software configuration partition.
              This contains data that changes software behavior in the ROM, for
              example enabling defensive features in ROM or selecting failure
              modes if verification fails.
              '''
            iskeymgr_creator: false
            iskeymgr_owner: false
            size: 976
            offset: 264
          }
          {
            name: OWNERSHIP_SLOT_STATE
            variant: Unbuffered
            absorb: false
            secret: false
            sw_digest: false
            hw_digest: false
            write_lock: None
            read_lock: CSR
            key_sel: NoKey
            integrity: true
            bkout_type: false
            zeroizable: true
            items:
            [
              {
                name: OWNERSHIP_SLOT_STATE_ROT_OWNER_AUTH
                size: 16
                desc:
                  '''
                  Creator Ownership transfer state management
                  OWNERSHIP_ST_RAW:       ownership not yet claimed (factory default)
                  OWNERSHIP_ST_LOCKED0:   first ownership slot claimed
                  OWNERSHIP_ST_RELEASED0: first ownership slot released (assets have been cleared, ready to xfer)
                  OWNERSHIP_ST_LOCKED1:   second ownership slot claimed
                  OWNERSHIP_ST_SCRAPPED:  scrap state - terminal
                  '''
                isdigest: false
                iszer: false
                ismubi: false
                iskeymgr_creator: false
                iskeymgr_owner: false
                inv_default: 0
                offset: 1240
              }
              {
                name: OWNERSHIP_SLOT_STATE_PLAT_INTEG_AUTH
                size: 16
                desc:
                  '''
                  Creator Ownership transfer state management
                  OWNERSHIP_ST_RAW:       ownership not yet claimed (factory default)
                  OWNERSHIP_ST_LOCKED0:   first ownership slot claimed
                  OWNERSHIP_ST_RELEASED0: first ownership slot released (assets have been cleared, ready to xfer)
                  OWNERSHIP_ST_LOCKED1:   second ownership slot claimed
                  OWNERSHIP_ST_SCRAPPED:  scrap state - terminal
                  '''
                isdigest: false
                iszer: false
                ismubi: false
                iskeymgr_creator: false
                iskeymgr_owner: false
                inv_default: 0
                offset: 1256
              }
              {
                name: OWNERSHIP_SLOT_STATE_PLAT_OWNER_AUTH
                size: 16
                desc:
                  '''
                  Creator Ownership transfer state management
                  OWNERSHIP_ST_RAW:       ownership not yet claimed (factory default)
                  OWNERSHIP_ST_LOCKED0:   first ownership slot claimed
                  OWNERSHIP_ST_RELEASED0: first ownership slot released (assets have been cleared, ready to xfer)
                  OWNERSHIP_ST_LOCKED1:   second ownership slot claimed
                  OWNERSHIP_ST_RELEASED1: second ownership slot released (assets have been cleared, ready to xfer)
                  OWNERSHIP_ST_LOCKED2:   third ownership slot claimed
                  OWNERSHIP_ST_RELEASED2: third ownership slot released (assets have been cleared, ready to xfer)
                  OWNERSHIP_ST_LOCKED3:   fourth ownership slot claimed
                  OWNERSHIP_ST_SCRAPPED:  scrap state - terminal
                  '''
                isdigest: false
                iszer: false
                ismubi: false
                iskeymgr_creator: false
                iskeymgr_owner: false
                inv_default: 0
                offset: 1272
              }
              {
                name: OWNERSHIP_SLOT_STATE_ZER
                size: 8
                offset: 1288
                ismubi: false
                isdigest: false
                iszer: true
                inv_default: 0
                iskeymgr_creator: false
                iskeymgr_owner: false
              }
            ]
            desc:
              '''
              SW managed asset ownership states partition.

              Multi-bit enable value for the tracking the asset ownership states.
              Note that the states can be written multiple times in a device lifetime.
              The values to be written are engineered in the same way as the LC_CTRL
              state encoding words so that the ECC encoding remains valid even after
              updating the values.

              The constants can be found in the lc_ctrl_state_pkg.sv package.

              The programming order has to adhere to:

              OWNERSHIP_ST_RAW (factory all-zero state) ->
              OWNERSHIP_ST_LOCKED0 ->
              OWNERSHIP_ST_RELEASED0 ->
              ...
              OWNERSHIP_ST_SCRAPPED

              Note that if there are less than 4 slots available the higher slot states
              become logically equivalent to OWNERSHIP_SCRAPPED (firmware has to handle
              this correctly).
              '''
            iskeymgr_creator: false
            iskeymgr_owner: false
            size: 56
            offset: 1240
          }
          {
            name: ROT_CREATOR_IDENTITY
            variant: Unbuffered
            absorb: false
            secret: false
            sw_digest: true
            hw_digest: false
            write_lock: Digest
            read_lock: CSR
            key_sel: NoKey
            integrity: true
            bkout_type: false
            zeroizable: true
            items:
            [
              {
                name: ROT_CREATOR_IDENTITY_CERT
                size: 768
                desc:
                  '''
                  RoT Device Identity Certificate endorsed by the Silicon Creator stable PKI (off device).
                  It is expected to be provisioned at Factory Testing (FT) stage when LC = DEV or PROD.
                  Provisioning happens through a secured channel between the DUT and the HSM, i.e. the key
                  is protected against supply-chain and manufacturing attacks.
                  '''
                isdigest: false
                iszer: false
                ismubi: false
                iskeymgr_creator: false
                iskeymgr_owner: false
                inv_default: 0
                offset: 1296
              }
              {
                name: ROT_CREATOR_IDENTITY_CERT_CMAC
                size: 16
                desc: A Cipher-based MAC for the RoT Device Identity Certificate.
                isdigest: false
                iszer: false
                ismubi: false
                iskeymgr_creator: false
                iskeymgr_owner: false
                inv_default: 0
                offset: 2064
              }
              {
                name: ROT_CREATOR_IDENTITY_DIGEST
                size: 8
                offset: 2080
                ismubi: false
                isdigest: true
                iszer: false
                inv_default: 15710116330355108305
                iskeymgr_creator: false
                iskeymgr_owner: false
              }
              {
                name: ROT_CREATOR_IDENTITY_ZER
                size: 8
                offset: 2088
                ismubi: false
                isdigest: false
                iszer: true
                inv_default: 0
                iskeymgr_creator: false
                iskeymgr_owner: false
              }
            ]
            desc: Software managed partition for the RoT Creator identity.
            iskeymgr_creator: false
            iskeymgr_owner: false
            size: 800
            offset: 1296
          }
          {
            name: ROT_OWNER_AUTH_SLOT0
            variant: Unbuffered
            absorb: false
            secret: false
            sw_digest: true
            hw_digest: false
            write_lock: Digest
            read_lock: CSR
            key_sel: NoKey
            integrity: true
            bkout_type: false
            zeroizable: true
            items:
            [
              {
                name: ROT_OWNER_AUTH_SLOT0_NON_RAW_MFW_CODESIGN_KEY_TYPE
                size: 4
                isdigest: false
                iszer: false
                ismubi: false
                iskeymgr_creator: false
                iskeymgr_owner: false
                inv_default: 0
                offset: 2096
              }
              {
                name: ROT_OWNER_AUTH_SLOT0_NON_RAW_MFW_CODESIGN_KEY_ROLE
                size: 4
                isdigest: false
                iszer: false
                ismubi: false
                iskeymgr_creator: false
                iskeymgr_owner: false
                inv_default: 0
                offset: 2100
              }
              {
                name: ROT_OWNER_AUTH_SLOT0_NON_RAW_MFW_CODESIGN_KEY
                size: 64
                desc:
                  '''
                  Public Key used to verify manufacturing and debug firmware images.
                  Key Type: ECC NIST-P256 Curve.
                  It is expected to be provisioned at Final Test (FT) stage when LC = TEST_UNLOCKED.
                  Together with the ROM2_PATCH_SIGVERIFY_KEY and KEYMANIFEST_KEY keys, and their
                  associated device ID and metadata (stored in resp. KEY_DEVICE_ID and KEY_METADATA),
                  this key is signed with a Silicon Creator endorsed ECDSA P-256 key in order to protect
                  it from supply-chain and manufacturing attacks.
                  '''
                isdigest: false
                iszer: false
                ismubi: false
                iskeymgr_creator: false
                iskeymgr_owner: false
                inv_default: 0
                offset: 2104
              }
              {
                name: ROT_OWNER_AUTH_SLOT0_ROM2_PATCH_SIGVERIFY_KEY_TYPE
                size: 4
                isdigest: false
                iszer: false
                ismubi: false
                iskeymgr_creator: false
                iskeymgr_owner: false
                inv_default: 0
                offset: 2168
              }
              {
                name: ROT_OWNER_AUTH_SLOT0_ROM2_PATCH_SIGVERIFY_KEY_ROLE
                size: 4
                isdigest: false
                iszer: false
                ismubi: false
                iskeymgr_creator: false
                iskeymgr_owner: false
                inv_default: 0
                offset: 2172
              }
              {
                name: ROT_OWNER_AUTH_SLOT0_ROM2_PATCH_SIGVERIFY_KEY
                size: 64
                desc:
                  '''
                  Public Key used to verify the ROM2 OTP based patch.
                  Key Type: ECC NIST-P256 Curve.
                  It is expected to be provisioned at Final Test (FT) stage when LC = TEST_UNLOCKED.
                  Together with the NON_RAW_MFW_CODESIGN_KEY and KEYMANIFEST_KEY keys, and their
                  associated device ID and metadata (stored in resp. KEY_DEVICE_ID and KEY_METADATA),
                  this key is signed with a Silicon Creator endorsed ECDSA P-256 key in order to protect
                  it from supply-chain and manufacturing attacks.
                  '''
                isdigest: false
                iszer: false
                ismubi: false
                iskeymgr_creator: false
                iskeymgr_owner: false
                inv_default: 0
                offset: 2176
              }
              {
                name: ROT_OWNER_AUTH_SLOT0_KEYMANIFEST_KEY_TYPE
                size: 4
                isdigest: false
                iszer: false
                ismubi: false
                iskeymgr_creator: false
                iskeymgr_owner: false
                inv_default: 0
                offset: 2240
              }
              {
                name: ROT_OWNER_AUTH_SLOT0_KEYMANIFEST_KEY_ROLE
                size: 4
                isdigest: false
                iszer: false
                ismubi: false
                iskeymgr_creator: false
                iskeymgr_owner: false
                inv_default: 0
                offset: 2244
              }
              {
                name: ROT_OWNER_AUTH_SLOT0_KEYMANIFEST_KEY
                size: 64
                desc:
                  '''
                  Public Key used to verify the RoT Creator (a.k.a. Silicon Creator) Key Manifest.
                  Key Type: ECC NIST-P256 Curve.
                  Together with the ROM2_PATCH_SIGVERIFY_KEY and NON_RAW_MFW_CODESIGN_KEY keys, and their
                  associated device ID and metadata (stored in resp. KEY_DEVICE_ID and KEY_METADATA),
                  this key is signed with a Silicon Creator endorsed ECDSA P-256 key in order to protect
                  it from supply-chain and manufacturing attacks.
                  '''
                isdigest: false
                iszer: false
                ismubi: false
                iskeymgr_creator: false
                iskeymgr_owner: false
                inv_default: 0
                offset: 2248
              }
              {
                name: ROT_OWNER_AUTH_SLOT0_KEY_DEVICE_ID
                size: 32
                isdigest: false
                iszer: false
                ismubi: false
                iskeymgr_creator: false
                iskeymgr_owner: false
                inv_default: 0
                offset: 2312
              }
              {
                name: ROT_OWNER_AUTH_SLOT0_KEY_METADATA
                size: 16
                isdigest: false
                iszer: false
                ismubi: false
                iskeymgr_creator: false
                iskeymgr_owner: false
                inv_default: 0
                offset: 2344
              }
              {
                name: ROT_OWNER_AUTH_SLOT0_KEY_SIGNATURE
                size: 64
                desc:
                  '''
                  ECDSA P-256 signature of the NON_RAW_MFW_CODESIGN_KEY,
                  ROM2_PATCH_SIGVERIFY_KEY, KEYMANIFEST_KEY, KEY_DEVICE_ID and KEY_METADATA fields in
                  this partition.
                  As those three keys are expected to be provisioned at Final Test (FT) stage when
                  LC = TEST_UNLOCKED, this signatures aims at protecting them from supply-chain and
                  manufacturing attacks.
                  ROM images must include the corresponding signing key in order to verify all three
                  signatures.
                  '''
                isdigest: false
                iszer: false
                ismubi: false
                iskeymgr_creator: false
                iskeymgr_owner: false
                inv_default: 0
                offset: 2360
              }
              {
                name: ROT_OWNER_AUTH_SLOT0_DIGEST
                size: 8
                offset: 2424
                ismubi: false
                isdigest: true
                iszer: false
                inv_default: 157542749280826575
                iskeymgr_creator: false
                iskeymgr_owner: false
              }
              {
                name: ROT_OWNER_AUTH_SLOT0_ZER
                size: 8
                offset: 2432
                ismubi: false
                isdigest: false
                iszer: true
                inv_default: 0
                iskeymgr_creator: false
                iskeymgr_owner: false
              }
            ]
            desc: Software managed partition for the first RoT Owner (a.k.a. RoT Creator) key manifest.
            iskeymgr_creator: false
            iskeymgr_owner: false
            size: 344
            offset: 2096
          }
          {
            name: ROT_OWNER_AUTH_SLOT1
            variant: Unbuffered
            absorb: false
            secret: false
            sw_digest: true
            hw_digest: false
            write_lock: Digest
            read_lock: CSR
            key_sel: NoKey
            integrity: true
            bkout_type: false
            zeroizable: true
            items:
            [
              {
                name: ROT_OWNER_AUTH_SLOT1_KEYMANIFEST_KEY_TYPE
                size: 4
                isdigest: false
                iszer: false
                ismubi: false
                iskeymgr_creator: false
                iskeymgr_owner: false
                inv_default: 0
                offset: 2440
              }
              {
                name: ROT_OWNER_AUTH_SLOT1_KEYMANIFEST_KEY_ROLE
                size: 4
                isdigest: false
                iszer: false
                ismubi: false
                iskeymgr_creator: false
                iskeymgr_owner: false
                inv_default: 0
                offset: 2444
              }
              {
                name: ROT_OWNER_AUTH_SLOT1_KEYMANIFEST_KEY
                size: 64
                desc:
                  '''
                  Public Key used to verify the RoT Owner (a.k.a. Silicon Owner) Key Manifest.
                  Key Type: ECC NIST-P256 Curve.
                  It is expected to be provisioned as part of the RoT Owner intra-role ownership transfer
                  process, when LC = PROD.
                  Provisioning happens through an Ownership Claim operation, after the previous RoT
                  Owner completed a Relinquish operation.
                  '''
                isdigest: false
                iszer: false
                ismubi: false
                iskeymgr_creator: false
                iskeymgr_owner: false
                inv_default: 0
                offset: 2448
              }
              {
                name: ROT_OWNER_AUTH_SLOT1_UNLOCK4XFER_KEY_TYPE
                size: 4
                isdigest: false
                iszer: false
                ismubi: false
                iskeymgr_creator: false
                iskeymgr_owner: false
                inv_default: 0
                offset: 2512
              }
              {
                name: ROT_OWNER_AUTH_SLOT1_UNLOCK4XFER_KEY_ROLE
                size: 4
                isdigest: false
                iszer: false
                ismubi: false
                iskeymgr_creator: false
                iskeymgr_owner: false
                inv_default: 0
                offset: 2516
              }
              {
                name: ROT_OWNER_AUTH_SLOT1_UNLOCK4XFER_KEY
                size: 64
                desc:
                  '''
                  Public Key used to verify the RoT Owner Unlock Ownership firmware image.
                  Key Type: ECC NIST-P256 Curve.
                  It is expected to be provisioned as part of the RoT Owner intra-role ownership transfer
                  process, when LC = PROD.
                  Provisioning happens through an Ownership Claim operation, after the previous RoT
                  Owner completed a Relinquish operation.
                  '''
                isdigest: false
                iszer: false
                ismubi: false
                iskeymgr_creator: false
                iskeymgr_owner: false
                inv_default: 0
                offset: 2520
              }
              {
                name: ROT_OWNER_AUTH_SLOT1_DIGEST
                size: 8
                offset: 2584
                ismubi: false
                isdigest: true
                iszer: false
                inv_default: 1525114536255331369
                iskeymgr_creator: false
                iskeymgr_owner: false
              }
              {
                name: ROT_OWNER_AUTH_SLOT1_ZER
                size: 8
                offset: 2592
                ismubi: false
                isdigest: false
                iszer: true
                inv_default: 0
                iskeymgr_creator: false
                iskeymgr_owner: false
              }
            ]
            desc: Software managed RoT Owner slot 1 partition.
            iskeymgr_creator: false
            iskeymgr_owner: false
            size: 160
            offset: 2440
          }
          {
            name: PLAT_INTEG_AUTH_SLOT0
            variant: Unbuffered
            absorb: false
            secret: false
            sw_digest: true
            hw_digest: false
            write_lock: Digest
            read_lock: CSR
            key_sel: NoKey
            integrity: true
            bkout_type: false
            zeroizable: true
            items:
            [
              {
                name: PLAT_INTEG_AUTH_SLOT0_KEYMANIFEST_KEY_TYPE
                size: 4
                isdigest: false
                iszer: false
                ismubi: false
                iskeymgr_creator: false
                iskeymgr_owner: false
                inv_default: 0
                offset: 2600
              }
              {
                name: PLAT_INTEG_AUTH_SLOT0_KEYMANIFEST_KEY_ROLE
                size: 4
                isdigest: false
                iszer: false
                ismubi: false
                iskeymgr_creator: false
                iskeymgr_owner: false
                inv_default: 0
                offset: 2604
              }
              {
                name: PLAT_INTEG_AUTH_SLOT0_KEYMANIFEST_KEY
                size: 64
                desc:
                  '''
                  Public Key used to verify the Platform Integrator Key Manifest.
                  Key Type: ECC NIST-P256 Curve.
                  This should be provisioned during the Platform Integrator Activation process, at the Platform
                  Integrator's manufacturing facilities.
                  The initial Platform Integrator provisions its Key Manifest public key using the provisioning
                  boot service provided by the current RoT Owner.
                  '''
                isdigest: false
                iszer: false
                ismubi: false
                iskeymgr_creator: false
                iskeymgr_owner: false
                inv_default: 0
                offset: 2608
              }
              {
                name: PLAT_INTEG_AUTH_SLOT0_UNLOCK4XFER_KEY_TYPE
                size: 4
                isdigest: false
                iszer: false
                ismubi: false
                iskeymgr_creator: false
                iskeymgr_owner: false
                inv_default: 0
                offset: 2672
              }
              {
                name: PLAT_INTEG_AUTH_SLOT0_UNLOCK4XFER_KEY_ROLE
                size: 4
                isdigest: false
                iszer: false
                ismubi: false
                iskeymgr_creator: false
                iskeymgr_owner: false
                inv_default: 0
                offset: 2676
              }
              {
                name: PLAT_INTEG_AUTH_SLOT0_UNLOCK4XFER_KEY
                size: 64
                desc:
                  '''
                  Public Key used to verify the Platform Integrator Unlock Ownership firmware image.
                  Key Type: ECC NIST-P256 Curve.
                  This should be provisioned during the Platform Integrator Activation process, at the Platform
                  Integrator's manufacturing facilities.
                  The initial Platform Integrator provisions its Key Manifest public key using the provisioning
                  boot service provided by the current RoT Owner.
                  '''
                isdigest: false
                iszer: false
                ismubi: false
                iskeymgr_creator: false
                iskeymgr_owner: false
                inv_default: 0
                offset: 2680
              }
              {
                name: PLAT_INTEG_AUTH_SLOT0_DIGEST
                size: 8
                offset: 2744
                ismubi: false
                isdigest: true
                iszer: false
                inv_default: 2505618692864360002
                iskeymgr_creator: false
                iskeymgr_owner: false
              }
              {
                name: PLAT_INTEG_AUTH_SLOT0_ZER
                size: 8
                offset: 2752
                ismubi: false
                isdigest: false
                iszer: true
                inv_default: 0
                iskeymgr_creator: false
                iskeymgr_owner: false
              }
            ]
            desc: Software managed Platform Integrator slot 0 partition.
            iskeymgr_creator: false
            iskeymgr_owner: false
            size: 160
            offset: 2600
          }
          {
            name: PLAT_INTEG_AUTH_SLOT1
            variant: Unbuffered
            absorb: false
            secret: false
            sw_digest: true
            hw_digest: false
            write_lock: Digest
            read_lock: CSR
            key_sel: NoKey
            integrity: true
            bkout_type: false
            zeroizable: true
            items:
            [
              {
                name: PLAT_INTEG_AUTH_SLOT1_KEYMANIFEST_KEY_TYPE
                size: 4
                isdigest: false
                iszer: false
                ismubi: false
                iskeymgr_creator: false
                iskeymgr_owner: false
                inv_default: 0
                offset: 2760
              }
              {
                name: PLAT_INTEG_AUTH_SLOT1_KEYMANIFEST_KEY_ROLE
                size: 4
                isdigest: false
                iszer: false
                ismubi: false
                iskeymgr_creator: false
                iskeymgr_owner: false
                inv_default: 0
                offset: 2764
              }
              {
                name: PLAT_INTEG_AUTH_SLOT1_KEYMANIFEST_KEY
                size: 64
                desc:
                  '''
                  Public Key used to verify the Platform Integrator Key Manifest.
                  Key Type: ECC NIST-P256 Curve.
                  This should be provisioned during the Platform Integrator intra-role ownership transfer
                  process when the lifecycle state (LC) is PROD. Provisioning occurs via an Ownership Claim
                  operation after the previous Platform Integrator completes a Relinquish operation.
                  '''
                isdigest: false
                iszer: false
                ismubi: false
                iskeymgr_creator: false
                iskeymgr_owner: false
                inv_default: 0
                offset: 2768
              }
              {
                name: PLAT_INTEG_AUTH_SLOT1_UNLOCK4XFER_KEY_TYPE
                size: 4
                isdigest: false
                iszer: false
                ismubi: false
                iskeymgr_creator: false
                iskeymgr_owner: false
                inv_default: 0
                offset: 2832
              }
              {
                name: PLAT_INTEG_AUTH_SLOT1_UNLOCK4XFER_KEY_ROLE
                size: 4
                isdigest: false
                iszer: false
                ismubi: false
                iskeymgr_creator: false
                iskeymgr_owner: false
                inv_default: 0
                offset: 2836
              }
              {
                name: PLAT_INTEG_AUTH_SLOT1_UNLOCK4XFER_KEY
                size: 64
                desc:
                  '''
                  Public Key used to verify the Platform Integrator Unlock Ownership firmware image
                  Key Type: ECC NIST-P256 Curve.
                  This should be provisioned during the Platform Integrator intra-role ownership transfer
                  process when the lifecycle state (LC) is PROD. Provisioning occurs via an Ownership Claim
                  operation after the previous Platform Integrator completes a Relinquish operation.
                  '''
                isdigest: false
                iszer: false
                ismubi: false
                iskeymgr_creator: false
                iskeymgr_owner: false
                inv_default: 0
                offset: 2840
              }
              {
                name: PLAT_INTEG_AUTH_SLOT1_DIGEST
                size: 8
                offset: 2904
                ismubi: false
                isdigest: true
                iszer: false
                inv_default: 7205140007485333107
                iskeymgr_creator: false
                iskeymgr_owner: false
              }
              {
                name: PLAT_INTEG_AUTH_SLOT1_ZER
                size: 8
                offset: 2912
                ismubi: false
                isdigest: false
                iszer: true
                inv_default: 0
                iskeymgr_creator: false
                iskeymgr_owner: false
              }
            ]
            desc: Software managed Platform Integrator slot 1 partition.
            iskeymgr_creator: false
            iskeymgr_owner: false
            size: 160
            offset: 2760
          }
          {
            name: PLAT_OWNER_AUTH_SLOT0
            variant: Unbuffered
            absorb: false
            secret: false
            sw_digest: true
            hw_digest: false
            write_lock: Digest
            read_lock: CSR
            key_sel: NoKey
            integrity: true
            bkout_type: false
            zeroizable: true
            items:
            [
              {
                name: PLAT_OWNER_AUTH_SLOT0_KEYMANIFEST_KEY_TYPE
                size: 4
                isdigest: false
                iszer: false
                ismubi: false
                iskeymgr_creator: false
                iskeymgr_owner: false
                inv_default: 0
                offset: 2920
              }
              {
                name: PLAT_OWNER_AUTH_SLOT0_KEYMANIFEST_KEY_ROLE
                size: 4
                isdigest: false
                iszer: false
                ismubi: false
                iskeymgr_creator: false
                iskeymgr_owner: false
                inv_default: 0
                offset: 2924
              }
              {
                name: PLAT_OWNER_AUTH_SLOT0_KEYMANIFEST_KEY
                size: 64
                desc:
                  '''
                  Public Key used to verify the Platform Owner Key Manifest.
                  Key Type: ECC NIST-P256 Curve.
                  This should be provisioned during the Platform Owner Activation process, at the Platform
                  Owner's facilities.
                  The initial Platform Owner provisions its Key Manifest public key using the provisioning
                  boot service provided by the current RoT Owner.
                  '''
                isdigest: false
                iszer: false
                ismubi: false
                iskeymgr_creator: false
                iskeymgr_owner: false
                inv_default: 0
                offset: 2928
              }
              {
                name: PLAT_OWNER_AUTH_SLOT0_UNLOCK4XFER_KEY_TYPE
                size: 4
                isdigest: false
                iszer: false
                ismubi: false
                iskeymgr_creator: false
                iskeymgr_owner: false
                inv_default: 0
                offset: 2992
              }
              {
                name: PLAT_OWNER_AUTH_SLOT0_UNLOCK4XFER_KEY_ROLE
                size: 4
                isdigest: false
                iszer: false
                ismubi: false
                iskeymgr_creator: false
                iskeymgr_owner: false
                inv_default: 0
                offset: 2996
              }
              {
                name: PLAT_OWNER_AUTH_SLOT0_UNLOCK4XFER_KEY
                size: 64
                desc:
                  '''
                  Public Key used to verify the Platform Owner Unlock Ownership firmware image.
                  Key Type: ECC NIST-P256 Curve.
                  This should be provisioned during the Platform Owner Activation process, at the Platform
                  Owner's facilities.
                  The initial Platform Owner provisions its Key Manifest public key using the provisioning
                  boot service provided by the current RoT Owner.
                  '''
                isdigest: false
                iszer: false
                ismubi: false
                iskeymgr_creator: false
                iskeymgr_owner: false
                inv_default: 0
                offset: 3000
              }
              {
                name: PLAT_OWNER_AUTH_SLOT0_DIGEST
                size: 8
                offset: 3064
                ismubi: false
                isdigest: true
                iszer: false
                inv_default: 15422691379567619171
                iskeymgr_creator: false
                iskeymgr_owner: false
              }
              {
                name: PLAT_OWNER_AUTH_SLOT0_ZER
                size: 8
                offset: 3072
                ismubi: false
                isdigest: false
                iszer: true
                inv_default: 0
                iskeymgr_creator: false
                iskeymgr_owner: false
              }
            ]
            desc: Software managed Platform Owner slot 0 partition.
            iskeymgr_creator: false
            iskeymgr_owner: false
            size: 160
            offset: 2920
          }
          {
            name: PLAT_OWNER_AUTH_SLOT1
            variant: Unbuffered
            absorb: false
            secret: false
            sw_digest: true
            hw_digest: false
            write_lock: Digest
            read_lock: CSR
            key_sel: NoKey
            integrity: true
            bkout_type: false
            zeroizable: true
            items:
            [
              {
                name: PLAT_OWNER_AUTH_SLOT1_KEYMANIFEST_KEY_TYPE
                size: 4
                isdigest: false
                iszer: false
                ismubi: false
                iskeymgr_creator: false
                iskeymgr_owner: false
                inv_default: 0
                offset: 3080
              }
              {
                name: PLAT_OWNER_AUTH_SLOT1_KEYMANIFEST_KEY_ROLE
                size: 4
                isdigest: false
                iszer: false
                ismubi: false
                iskeymgr_creator: false
                iskeymgr_owner: false
                inv_default: 0
                offset: 3084
              }
              {
                name: PLAT_OWNER_AUTH_SLOT1_KEYMANIFEST_KEY
                size: 64
                desc:
                  '''
                  Public Key used to verify the Platform Owner Key Manifest.
                  Key Type: ECC NIST-P256 Curve.
                  This should be provisioned during the Platform Owner intra-role ownership transfer
                  process when the lifecycle state (LC) is PROD. Provisioning occurs via an Ownership Claim
                  operation after the previous Platform Owner completes a Relinquish operation.
                  '''
                isdigest: false
                iszer: false
                ismubi: false
                iskeymgr_creator: false
                iskeymgr_owner: false
                inv_default: 0
                offset: 3088
              }
              {
                name: PLAT_OWNER_AUTH_SLOT1_UNLOCK4XFER_KEY_TYPE
                size: 4
                isdigest: false
                iszer: false
                ismubi: false
                iskeymgr_creator: false
                iskeymgr_owner: false
                inv_default: 0
                offset: 3152
              }
              {
                name: PLAT_OWNER_AUTH_SLOT1_UNLOCK4XFER_KEY_ROLE
                size: 4
                isdigest: false
                iszer: false
                ismubi: false
                iskeymgr_creator: false
                iskeymgr_owner: false
                inv_default: 0
                offset: 3156
              }
              {
                name: PLAT_OWNER_AUTH_SLOT1_UNLOCK4XFER_KEY
                size: 64
                desc:
                  '''
                  Public Key used to verify the Platform Owner Unlock Ownership firmware image.
                  Key Type: ECC NIST-P256 Curve.
                  This should be provisioned during the Platform Owner intra-role ownership transfer
                  process when the lifecycle state (LC) is PROD. Provisioning occurs via an Ownership Claim
                  operation after the previous Platform Owner completes a Relinquish operation.
                  '''
                isdigest: false
                iszer: false
                ismubi: false
                iskeymgr_creator: false
                iskeymgr_owner: false
                inv_default: 0
                offset: 3160
              }
              {
                name: PLAT_OWNER_AUTH_SLOT1_DIGEST
                size: 8
                offset: 3224
                ismubi: false
                isdigest: true
                iszer: false
                inv_default: 11795428238417073728
                iskeymgr_creator: false
                iskeymgr_owner: false
              }
              {
                name: PLAT_OWNER_AUTH_SLOT1_ZER
                size: 8
                offset: 3232
                ismubi: false
                isdigest: false
                iszer: true
                inv_default: 0
                iskeymgr_creator: false
                iskeymgr_owner: false
              }
            ]
            desc: Software managed Platform Owner slot 1 partition.
            iskeymgr_creator: false
            iskeymgr_owner: false
            size: 160
            offset: 3080
          }
          {
            name: PLAT_OWNER_AUTH_SLOT2
            variant: Unbuffered
            absorb: false
            secret: false
            sw_digest: true
            hw_digest: false
            write_lock: Digest
            read_lock: CSR
            key_sel: NoKey
            integrity: true
            bkout_type: false
            zeroizable: true
            items:
            [
              {
                name: PLAT_OWNER_AUTH_SLOT2_KEYMANIFEST_KEY_TYPE
                size: 4
                isdigest: false
                iszer: false
                ismubi: false
                iskeymgr_creator: false
                iskeymgr_owner: false
                inv_default: 0
                offset: 3240
              }
              {
                name: PLAT_OWNER_AUTH_SLOT2_KEYMANIFEST_KEY_ROLE
                size: 4
                isdigest: false
                iszer: false
                ismubi: false
                iskeymgr_creator: false
                iskeymgr_owner: false
                inv_default: 0
                offset: 3244
              }
              {
                name: PLAT_OWNER_AUTH_SLOT2_KEYMANIFEST_KEY
                size: 64
                desc:
                  '''
                  Public Key used to verify the Platform Owner Key Manifest.
                  Key Type: ECC NIST-P256 Curve.
                  This should be provisioned during the Platform Owner intra-role ownership transfer
                  process when the lifecycle state (LC) is PROD. Provisioning occurs via an Ownership Claim
                  operation after the previous Platform Owner completes a Relinquish operation.
                  '''
                isdigest: false
                iszer: false
                ismubi: false
                iskeymgr_creator: false
                iskeymgr_owner: false
                inv_default: 0
                offset: 3248
              }
              {
                name: PLAT_OWNER_AUTH_SLOT2_UNLOCK4XFER_KEY_TYPE
                size: 4
                isdigest: false
                iszer: false
                ismubi: false
                iskeymgr_creator: false
                iskeymgr_owner: false
                inv_default: 0
                offset: 3312
              }
              {
                name: PLAT_OWNER_AUTH_SLOT2_UNLOCK4XFER_KEY_ROLE
                size: 4
                isdigest: false
                iszer: false
                ismubi: false
                iskeymgr_creator: false
                iskeymgr_owner: false
                inv_default: 0
                offset: 3316
              }
              {
                name: PLAT_OWNER_AUTH_SLOT2_UNLOCK4XFER_KEY
                size: 64
                desc:
                  '''
                  Public Key used to verify the Platform Owner Unlock Ownership firmware image.
                  Key Type: ECC NIST-P256 Curve.
                  This should be provisioned during the Platform Owner intra-role ownership transfer
                  process when the lifecycle state (LC) is PROD. Provisioning occurs via an Ownership Claim
                  operation after the previous Platform Owner completes a Relinquish operation.
                  '''
                isdigest: false
                iszer: false
                ismubi: false
                iskeymgr_creator: false
                iskeymgr_owner: false
                inv_default: 0
                offset: 3320
              }
              {
                name: PLAT_OWNER_AUTH_SLOT2_DIGEST
                size: 8
                offset: 3384
                ismubi: false
                isdigest: true
                iszer: false
                inv_default: 17244459621709600035
                iskeymgr_creator: false
                iskeymgr_owner: false
              }
              {
                name: PLAT_OWNER_AUTH_SLOT2_ZER
                size: 8
                offset: 3392
                ismubi: false
                isdigest: false
                iszer: true
                inv_default: 0
                iskeymgr_creator: false
                iskeymgr_owner: false
              }
            ]
            desc: Software managed Platform Owner slot 2 partition.
            iskeymgr_creator: false
            iskeymgr_owner: false
            size: 160
            offset: 3240
          }
          {
            name: PLAT_OWNER_AUTH_SLOT3
            variant: Unbuffered
            absorb: false
            secret: false
            sw_digest: true
            hw_digest: false
            write_lock: Digest
            read_lock: CSR
            key_sel: NoKey
            integrity: true
            bkout_type: false
            zeroizable: true
            items:
            [
              {
                name: PLAT_OWNER_AUTH_SLOT3_KEYMANIFEST_KEY_TYPE
                size: 4
                isdigest: false
                iszer: false
                ismubi: false
                iskeymgr_creator: false
                iskeymgr_owner: false
                inv_default: 0
                offset: 3400
              }
              {
                name: PLAT_OWNER_AUTH_SLOT3_KEYMANIFEST_KEY_ROLE
                size: 4
                isdigest: false
                iszer: false
                ismubi: false
                iskeymgr_creator: false
                iskeymgr_owner: false
                inv_default: 0
                offset: 3404
              }
              {
                name: PLAT_OWNER_AUTH_SLOT3_KEYMANIFEST_KEY
                size: 64
                desc:
                  '''
                  Public Key used to verify the Platform Owner Key Manifest.
                  Key Type: ECC NIST-P256 Curve.
                  This should be provisioned during the Platform Owner intra-role ownership transfer
                  process when the lifecycle state (LC) is PROD. Provisioning occurs via an Ownership Claim
                  operation after the previous Platform Owner completes a Relinquish operation.
                  '''
                isdigest: false
                iszer: false
                ismubi: false
                iskeymgr_creator: false
                iskeymgr_owner: false
                inv_default: 0
                offset: 3408
              }
              {
                name: PLAT_OWNER_AUTH_SLOT3_UNLOCK4XFER_KEY_TYPE
                size: 4
                isdigest: false
                iszer: false
                ismubi: false
                iskeymgr_creator: false
                iskeymgr_owner: false
                inv_default: 0
                offset: 3472
              }
              {
                name: PLAT_OWNER_AUTH_SLOT3_UNLOCK4XFER_KEY_ROLE
                size: 4
                isdigest: false
                iszer: false
                ismubi: false
                iskeymgr_creator: false
                iskeymgr_owner: false
                inv_default: 0
                offset: 3476
              }
              {
                name: PLAT_OWNER_AUTH_SLOT3_UNLOCK4XFER_KEY
                size: 64
                desc:
                  '''
                  Public Key used to verify the Platform Owner Unlock Ownership firmware image.
                  Key Type: ECC NIST-P256 Curve.
                  This should be provisioned during the Platform Owner intra-role ownership transfer
                  process when the lifecycle state (LC) is PROD. Provisioning occurs via an Ownership Claim
                  operation after the previous Platform Owner completes a Relinquish operation.
                  '''
                isdigest: false
                iszer: false
                ismubi: false
                iskeymgr_creator: false
                iskeymgr_owner: false
                inv_default: 0
                offset: 3480
              }
              {
                name: PLAT_OWNER_AUTH_SLOT3_DIGEST
                size: 8
                offset: 3544
                ismubi: false
                isdigest: true
                iszer: false
                inv_default: 9351492217133262506
                iskeymgr_creator: false
                iskeymgr_owner: false
              }
              {
                name: PLAT_OWNER_AUTH_SLOT3_ZER
                size: 8
                offset: 3552
                ismubi: false
                isdigest: false
                iszer: true
                inv_default: 0
                iskeymgr_creator: false
                iskeymgr_owner: false
              }
            ]
            desc: Software managed Platform Owner slot 3 partition.
            iskeymgr_creator: false
            iskeymgr_owner: false
            size: 160
            offset: 3400
          }
          {
            name: EXT_NVM
            variant: Unbuffered
            absorb: false
            secret: false
            sw_digest: false
            hw_digest: false
            write_lock: None
            read_lock: CSR
            key_sel: NoKey
            integrity: false
            bkout_type: false
            zeroizable: true
            items:
            [
              {
                name: EXT_NVM_ANTIREPLAY_FRESHNESS_CNT
                size: 1024
                desc:
                  '''
                  Fully SW managed partition
                  1 bit (double bit allocated for redundancy - i.e. 2 physical bits for every logical bit) per day
                  assuming 10 year product lifecycle, allocating 8192 bits of freshness protection.
                  Implemented as thermometer encoding. Redundant bit programming & logical OR-ing managed by
                  software. Cannot be ECC protected since different bits in a fuse row are programmed at different times.
                  '''
                isdigest: false
                iszer: false
                ismubi: false
                iskeymgr_creator: false
                iskeymgr_owner: false
                inv_default: 0
                offset: 3560
              }
              {
                name: EXT_NVM_ZER
                size: 8
                offset: 4584
                ismubi: false
                isdigest: false
                iszer: true
                inv_default: 0
                iskeymgr_creator: false
                iskeymgr_owner: false
              }
            ]
            desc: Anti-replay protection Strike Counters partition.
            iskeymgr_creator: false
            iskeymgr_owner: false
            size: 1032
            offset: 3560
          }
          {
            name: ROM_PATCH
            variant: Unbuffered
            absorb: true
            secret: false
            sw_digest: true
            hw_digest: false
            write_lock: Digest
            read_lock: CSR
            key_sel: NoKey
            integrity: true
            bkout_type: false
            zeroizable: true
            items:
            [
              {
                name: ROM_PATCH_DATA
                size: 9192
                desc:
                  '''
                  Fully SW managed partition
                  ROM patch section
                  signed patch(es)
                  Each patch Contains header, signature, patch match/redirect configuration and patch code
                  Please refer to the ROM boot & patching specification for Integrated OT for more details
                  '''
                isdigest: false
                iszer: false
                ismubi: false
                iskeymgr_creator: false
                iskeymgr_owner: false
                inv_default: 0
                offset: 4592
              }
              {
                name: ROM_PATCH_DIGEST
                size: 8
                offset: 15320
                ismubi: false
                isdigest: true
                iszer: false
                inv_default: 3482940500857016635
                iskeymgr_creator: false
                iskeymgr_owner: false
              }
              {
                name: ROM_PATCH_ZER
                size: 8
                offset: 15328
                ismubi: false
                isdigest: false
                iszer: true
                inv_default: 0
                iskeymgr_creator: false
                iskeymgr_owner: false
              }
            ]
            desc: ROM Patch Code section. May contain multiple signed ROM2 patches.
            iskeymgr_creator: false
            iskeymgr_owner: false
            size: 10744
            offset: 4592
          }
          {
            name: SOC_FUSES_CP
            variant: Unbuffered
            absorb: false
            secret: false
            sw_digest: true
            hw_digest: false
            write_lock: Digest
            read_lock: CSR
            key_sel: NoKey
            integrity: true
            bkout_type: false
            items:
            [
              {
                name: SOC_FUSES_CP1_DATA
                size: 256
                isdigest: false
                iszer: false
                ismubi: false
                iskeymgr_creator: false
                iskeymgr_owner: false
                inv_default: 0
                offset: 15336
              }
              {
                name: SOC_FUSES_CP2_DATA
                size: 128
                isdigest: false
                iszer: false
                ismubi: false
                iskeymgr_creator: false
                iskeymgr_owner: false
                inv_default: 0
                offset: 15592
              }
              {
                name: SOC_FUSES_CP_DIGEST
                size: 8
                offset: 15720
                ismubi: false
                isdigest: true
                iszer: false
                inv_default: 8187068425930011275
                iskeymgr_creator: false
                iskeymgr_owner: false
              }
            ]
            desc: SoC fuses partition for the Chip Probe (CP) manufacturing stage.
            iskeymgr_creator: false
            iskeymgr_owner: false
            zeroizable: false
            size: 392
            offset: 15336
          }
          {
            name: SOC_FUSES_FT
            variant: Unbuffered
            absorb: false
            secret: false
            sw_digest: true
            hw_digest: false
            write_lock: Digest
            read_lock: CSR
            key_sel: NoKey
            integrity: true
            bkout_type: false
            items:
            [
              {
                name: SOC_FUSES_FT1_DATA
                size: 384
                isdigest: false
                iszer: false
                ismubi: false
                iskeymgr_creator: false
                iskeymgr_owner: false
                inv_default: 0
                offset: 15728
              }
              {
                name: SOC_FUSES_FT2_DATA
                size: 3840
                isdigest: false
                iszer: false
                ismubi: false
                iskeymgr_creator: false
                iskeymgr_owner: false
                inv_default: 0
                offset: 16112
              }
              {
                name: SOC_FUSES_FT_DIGEST
                size: 8
                offset: 19952
                ismubi: false
                isdigest: true
                iszer: false
                inv_default: 13613404859098530722
                iskeymgr_creator: false
                iskeymgr_owner: false
              }
            ]
            desc: SoC fuses partition for the Factory Testing (FT) manufacturing stage.
            iskeymgr_creator: false
            iskeymgr_owner: false
            zeroizable: false
            size: 4232
            offset: 15728
          }
          {
            name: HW_CFG0
            variant: Buffered
            secret: false
            sw_digest: false
            hw_digest: true
            write_lock: Digest
            read_lock: None
            key_sel: NoKey
            integrity: true
            bkout_type: true
            zeroizable: true
            items:
            [
              {
                name: DEVICE_ID
                size: 32
                inv_default: 40501398844832094875114408663879061209118058814964110894288788264184189765987
                desc:
                  '''
                  Unique device identifier that is always exposed through the
                  lifecycle JTAG tap. See OpenTitan documentation on Device
                  Identifiers.
                  '''
                isdigest: false
                iszer: false
                ismubi: false
                iskeymgr_creator: false
                iskeymgr_owner: false
                offset: 19960
              }
              {
                name: HW_CFG0_DIGEST
                size: 8
                offset: 19992
                ismubi: false
                isdigest: true
                iszer: false
                inv_default: 13022557762012396181
                iskeymgr_creator: false
                iskeymgr_owner: false
              }
              {
                name: HW_CFG0_ZER
                size: 8
                offset: 20000
                ismubi: false
                isdigest: false
                iszer: true
                inv_default: 0
                iskeymgr_creator: false
                iskeymgr_owner: false
              }
            ]
            desc:
              '''
              Hardware configuration partition 0.
              This contains a device identifier.
              '''
            absorb: false
            iskeymgr_creator: false
            iskeymgr_owner: false
            size: 48
            offset: 19960
          }
          {
            name: HW_CFG1
            variant: Buffered
            secret: false
            sw_digest: false
            hw_digest: true
            write_lock: Digest
            read_lock: None
            key_sel: NoKey
            integrity: true
            bkout_type: true
            zeroizable: true
            items:
            [
              {
                name: EN_CSRNG_SW_APP_READ
                size: 1
                ismubi: true
                inv_default: 105
                desc:
                  '''
                  Enablement of CSRNG software application interface. A
                  kMultiBitBool8True value enables, while all other values
                  disable. Enablement is required to extract output from
                  CSRNG via software.
                  '''
                isdigest: false
                iszer: false
                iskeymgr_creator: false
                iskeymgr_owner: false
                offset: 20008
              }
              {
                name: EN_SRAM_IFETCH
                size: 1
                ismubi: true
                inv_default: 105
                desc:
                  '''
                  Enablement of execute from SRAM switch in the sram_ctrl (see
                  EXEC CSR). A kMultiBitBool8True value enables, while all
                  other values disable.
                  '''
                isdigest: false
                iszer: false
                iskeymgr_creator: false
                iskeymgr_owner: false
                offset: 20009
              }
              {
                name: HW_CFG1_DIGEST
                size: 8
                offset: 20016
                ismubi: false
                isdigest: true
                iszer: false
                inv_default: 6911337809181396458
                iskeymgr_creator: false
                iskeymgr_owner: false
              }
              {
                name: HW_CFG1_ZER
                size: 8
                offset: 20024
                ismubi: false
                isdigest: false
                iszer: true
                inv_default: 0
                iskeymgr_creator: false
                iskeymgr_owner: false
              }
            ]
            desc:
              '''
              Hardware configuration partition 1.
              This contains several hardware feature switches.
              '''
            absorb: false
            iskeymgr_creator: false
            iskeymgr_owner: false
            size: 24
            offset: 20008
          }
          {
            name: HW_CFG2
            variant: Buffered
            secret: false
            sw_digest: false
            hw_digest: true
            write_lock: Digest
            read_lock: None
            key_sel: NoKey
            integrity: true
            bkout_type: true
            zeroizable: true
            items:
            [
              {
                name: SOC_DBG_STATE
                size: 4
                inv_default: 0
                desc:
                  '''
                  Multi-bit enable value for the SOC debug authorization.
                  SOC_DBG_STATE will be written twice in a device lifetime. The
                  values to be written are engineered in the same way as the LC_CTRL
                  state encoding words: the ECC encoding remains valid even after
                  writing the second value on top of the first.
                  The constants can be found in the lc_ctrl_state_pkg.sv package.
                  The programming order has to adhere to:
                  SOC_DBG_RAW -> SOC_DBG_PRE_PROD -> SOC_DBG_PROD.
                  Encoding:
                  SOC_DBG_RAW: this value is all-zeroes and will be the NOP state;
                  the LC controller will take precedence.
                  SOC_DBG_PRE_PROD: this is where the ROT will be in PROD state
                  but SOC will be in the pre-production unlock state
                  SOC_DBG_PROD: this is the state where the SOC moves to production,
                  and the challenge-response based authentication protocol is
                  required to unlock SOC debug features
                  '''
                isdigest: false
                iszer: false
                ismubi: false
                iskeymgr_creator: false
                iskeymgr_owner: false
                offset: 20032
              }
              {
                name: MANUF_STATE
                size: 32
                inv_default: 28807926661450089350912902427449764760189093586386285279945247574061280326626
                desc: Field to capture the manufacturing state.
                isdigest: false
                iszer: false
                ismubi: false
                iskeymgr_creator: false
                iskeymgr_owner: false
                offset: 20036
              }
              {
                name: HW_CFG2_DIGEST
                size: 8
                offset: 20072
                ismubi: false
                isdigest: true
                iszer: false
                inv_default: 899833317950292790
                iskeymgr_creator: false
                iskeymgr_owner: false
              }
              {
                name: HW_CFG2_ZER
                size: 8
                offset: 20080
                ismubi: false
                isdigest: false
                iszer: true
                inv_default: 0
                iskeymgr_creator: false
                iskeymgr_owner: false
              }
            ]
            desc:
              '''
              Hardware configuration partition 2.
              This contains the SoC debug state and the manufacturing state.
              '''
            absorb: false
            iskeymgr_creator: false
            iskeymgr_owner: false
            size: 56
            offset: 20032
          }
          {
            name: SECRET0
            variant: Buffered
            secret: true
            sw_digest: false
            hw_digest: true
            write_lock: Digest
            read_lock: Digest
            key_sel: Secret0Key
            integrity: true
            bkout_type: false
            zeroizable: true
            items:
            [
              {
                name: TEST_UNLOCK_TOKEN
                inv_default: 182177191635167705173937616829284258131
                size: 16
                isdigest: false
                iszer: false
                ismubi: false
                iskeymgr_creator: false
                iskeymgr_owner: false
                offset: 20088
              }
              {
                name: TEST_EXIT_TOKEN
                inv_default: 113334116849525231636942507222723753753
                size: 16
                isdigest: false
                iszer: false
                ismubi: false
                iskeymgr_creator: false
                iskeymgr_owner: false
                offset: 20104
              }
              {
                name: SECRET0_DIGEST
                size: 8
                offset: 20120
                ismubi: false
                isdigest: true
                iszer: false
                inv_default: 6314004083024320026
                iskeymgr_creator: false
                iskeymgr_owner: false
              }
              {
                name: SECRET0_ZER
                size: 8
                offset: 20128
                ismubi: false
                isdigest: false
                iszer: true
                inv_default: 0
                iskeymgr_creator: false
                iskeymgr_owner: false
              }
            ]
            desc:
              '''
              Secret partition 0.
              This contains TEST lifecycle unlock tokens.
              '''
            absorb: false
            iskeymgr_creator: false
            iskeymgr_owner: false
            size: 48
            offset: 20088
          }
          {
            name: SECRET1
            variant: Buffered
            secret: true
            sw_digest: false
            hw_digest: true
            write_lock: Digest
            read_lock: Digest
            key_sel: Secret1Key
            integrity: true
            bkout_type: false
            zeroizable: true
            items:
            [
              {
                name: SRAM_DATA_KEY_SEED
                inv_default: 144061002521554659338161712592818323021
                size: 16
                isdigest: false
                iszer: false
                ismubi: false
                iskeymgr_creator: false
                iskeymgr_owner: false
                offset: 20136
              }
              {
                name: SECRET1_DIGEST
                size: 8
                offset: 20152
                ismubi: false
                isdigest: true
                iszer: false
                inv_default: 7881896702500903297
                iskeymgr_creator: false
                iskeymgr_owner: false
              }
              {
                name: SECRET1_ZER
                size: 8
                offset: 20160
                ismubi: false
                isdigest: false
                iszer: true
                inv_default: 0
                iskeymgr_creator: false
                iskeymgr_owner: false
              }
            ]
            desc:
              '''
              Secret partition 1.
              This contains the SRAM scrambling key seed.
              '''
            absorb: false
            iskeymgr_creator: false
            iskeymgr_owner: false
            size: 32
            offset: 20136
          }
          {
            name: SECRET2
            variant: Buffered
            secret: true
            sw_digest: false
            hw_digest: true
            write_lock: Digest
            read_lock: Digest
            key_sel: Secret2Key
            integrity: true
            bkout_type: false
            zeroizable: true
            items:
            [
              {
                name: RMA_TOKEN
                inv_default: 20436423525667573507812865364543471489
                size: 16
                isdigest: false
                iszer: false
                ismubi: false
                iskeymgr_creator: false
                iskeymgr_owner: false
                offset: 20168
              }
              {
                name: CREATOR_ROOT_KEY_SHARE0
                inv_default: 112937609658104557664720235924162363129336311225833316865587187995631593533954
                size: 32
                iskeymgr_creator: true
                isdigest: false
                iszer: false
                ismubi: false
                iskeymgr_owner: false
                offset: 20184
              }
              {
                name: CREATOR_ROOT_KEY_SHARE1
                inv_default: 67220341781509999623712039064327034068478221195092240487458626141753473591957
                size: 32
                iskeymgr_creator: true
                isdigest: false
                iszer: false
                ismubi: false
                iskeymgr_owner: false
                offset: 20216
              }
              {
                name: CREATOR_SEED
                inv_default: 96480450212453159177018096846071164700916456418131765720823327479747856687073
                size: 32
                iskeymgr_creator: true
                isdigest: false
                iszer: false
                ismubi: false
                iskeymgr_owner: false
                offset: 20248
              }
              {
                name: SECRET2_DIGEST
                size: 8
                offset: 20280
                ismubi: false
                isdigest: true
                iszer: false
                inv_default: 15563155100447382093
                iskeymgr_creator: false
                iskeymgr_owner: false
              }
              {
                name: SECRET2_ZER
                size: 8
                offset: 20288
                ismubi: false
                isdigest: false
                iszer: true
                inv_default: 0
                iskeymgr_creator: false
                iskeymgr_owner: false
              }
            ]
            desc:
              '''
              Secret partition 2.
              This contains RMA unlock token, creator root key, and creator seed.
              '''
            absorb: false
            iskeymgr_creator: true
            iskeymgr_owner: false
            size: 128
            offset: 20168
          }
          {
            name: SECRET3
            variant: Buffered
            secret: true
            sw_digest: false
            hw_digest: true
            write_lock: Digest
            read_lock: Digest
            key_sel: Secret3Key
            integrity: true
            bkout_type: false
            zeroizable: true
            items:
            [
              {
                name: OWNER_SEED
                inv_default: 19830000025622029573677199637204762658025534707517704692633306816785844362576
                size: 32
                iskeymgr_owner: true
                isdigest: false
                iszer: false
                ismubi: false
                iskeymgr_creator: false
                offset: 20296
              }
              {
                name: SECRET3_DIGEST
                size: 8
                offset: 20328
                ismubi: false
                isdigest: true
                iszer: false
                inv_default: 497467941740258226
                iskeymgr_creator: false
                iskeymgr_owner: false
              }
              {
                name: SECRET3_ZER
                size: 8
                offset: 20336
                ismubi: false
                isdigest: false
                iszer: true
                inv_default: 0
                iskeymgr_creator: false
                iskeymgr_owner: false
              }
            ]
            desc:
              '''
              Secret partition 3.
              This contains the owner seed.
              '''
            absorb: false
            iskeymgr_creator: false
            iskeymgr_owner: true
            size: 48
            offset: 20296
          }
          {
            name: SECRET4
            variant: Buffered
            secret: true
            sw_digest: false
            hw_digest: true
            write_lock: Digest
            read_lock: Digest
            key_sel: Secret4Key
            integrity: true
            bkout_type: false
            zeroizable: true
            items:
            [
              {
                name: UCIE_CTA_SEED
                inv_default: 94329640851707705236174009281698748906805576226486076261469603099328103605553
                size: 32
                iskeymgr_owner: true
                isdigest: false
                iszer: false
                ismubi: false
                iskeymgr_creator: false
                offset: 20344
              }
              {
                name: SECRET4_DIGEST
                size: 8
                offset: 20376
                ismubi: false
                isdigest: true
                iszer: false
                inv_default: 8803623895717951126
                iskeymgr_creator: false
                iskeymgr_owner: false
              }
              {
                name: SECRET4_ZER
                size: 8
                offset: 20384
                ismubi: false
                isdigest: false
                iszer: true
                inv_default: 0
                iskeymgr_creator: false
                iskeymgr_owner: false
              }
            ]
            desc:
              '''
              Secret partition 4.
              This contains the UCIe Chiplet Trust Anchor (CTA) seed.
              '''
            absorb: false
            iskeymgr_creator: false
            iskeymgr_owner: true
            size: 48
            offset: 20344
          }
          {
            name: LIFE_CYCLE
            variant: LifeCycle
            secret: false
            sw_digest: false
            hw_digest: false
            write_lock: None
            read_lock: None
            key_sel: NoKey
            integrity: true
            bkout_type: false
            items:
            [
              {
                name: LC_TRANSITION_CNT
                inv_default: 3496745244658753459073187228781572085007539322218764545726484915301415044255822991003568768409845418041547340349768
                size: 48
                isdigest: false
                iszer: false
                ismubi: false
                iskeymgr_creator: false
                iskeymgr_owner: false
                offset: 20392
              }
              {
                name: LC_STATE
                inv_default: 537198649743330568046723673202728193106326685176313773708748096931852411214074445109624675237285
                size: 40
                isdigest: false
                iszer: false
                ismubi: false
                iskeymgr_creator: false
                iskeymgr_owner: false
                offset: 20440
              }
            ]
            desc:
              '''
              Lifecycle partition.
              This contains lifecycle transition count and state. This partition
              cannot be locked since the life cycle state needs to advance to RMA
              in-field. Note that while this partition is not marked secret, it
              is not readable nor writable via the DAI. Only the LC controller
              can access this partition, and even via the LC controller it is not
              possible to read the raw manufacturing life cycle state in encoded
              form, since that encoding is considered a netlist secret. The LC
              controller only exposes a decoded version of this state.
              '''
            absorb: false
            iskeymgr_creator: false
            iskeymgr_owner: false
            zeroizable: false
            size: 88
            offset: 20392
          }
        ]
      }
    }
    {
      name: lc_ctrl
      type: lc_ctrl
      base_addrs:
      {
        regs:
        {
          hart: 0x30150000
        }
        dmi:
        {
          soc_dbg: 0x3000
        }
      }
      memory: {}
      param_list:
      [
        {
          name: RndCnstLcKeymgrDivInvalid
          desc: Diversification value used for all invalid life cycle states.
          type: lc_ctrl_pkg::lc_keymgr_div_t
          randcount: 128
          randtype: data
          name_top: RndCnstLcCtrlLcKeymgrDivInvalid
          default: 0xced883451de75a31a17164a55b7b63f3
          randwidth: 128
        }
        {
          name: RndCnstLcKeymgrDivTestUnlocked
          desc: Diversification value used for the TEST_UNLOCKED* life cycle states.
          type: lc_ctrl_pkg::lc_keymgr_div_t
          randcount: 128
          randtype: data
          name_top: RndCnstLcCtrlLcKeymgrDivTestUnlocked
          default: 0x6a1fdec4836f95ff7f93fc45f3a040f9
          randwidth: 128
        }
        {
          name: RndCnstLcKeymgrDivDev
          desc: Diversification value used for the DEV life cycle state.
          type: lc_ctrl_pkg::lc_keymgr_div_t
          randcount: 128
          randtype: data
          name_top: RndCnstLcCtrlLcKeymgrDivDev
          default: 0x68a66269f5adbc39874d0fd7595a4fe2
          randwidth: 128
        }
        {
          name: RndCnstLcKeymgrDivProduction
          desc: Diversification value used for the PROD/PROD_END life cycle states.
          type: lc_ctrl_pkg::lc_keymgr_div_t
          randcount: 128
          randtype: data
          name_top: RndCnstLcCtrlLcKeymgrDivProduction
          default: 0x904c507c7637b96ab96ea9fa5159e141
          randwidth: 128
        }
        {
          name: RndCnstLcKeymgrDivRma
          desc: Diversification value used for the RMA life cycle state.
          type: lc_ctrl_pkg::lc_keymgr_div_t
          randcount: 128
          randtype: data
          name_top: RndCnstLcCtrlLcKeymgrDivRma
          default: 0xfffe2acd7e9b4300dcb9e7fa3f9ee349
          randwidth: 128
        }
        {
          name: RndCnstInvalidTokens
          desc: Compile-time random bits used for invalid tokens in the token mux
          type: lc_ctrl_pkg::lc_token_mux_t
          randcount: 1024
          randtype: data
          name_top: RndCnstLcCtrlInvalidTokens
          default: 0x6ef3b39f0d0a3e8f034819b51a0bd224c742d5464afe5291c6af92400628db87e3122c8e7ab4b794c9fb8f1264e4c41cc56ad0fccde38a96d8fda7dd235685b52f3c80047adcc7e377dd041aaffbc1dfdab41c30880f64b57ceb7e57f7c98b052786311d5e97e8f11887b129eda81399ecef31c20932fea4be4c50e1b7dde95e
          randwidth: 1024
        }
      ]
    }
    {
      name: alert_handler
      type: alert_handler
      base_addrs:
      {
        null:
        {
          hart: 0x30160000
        }
      }
      memory: {}
      param_list:
      [
        {
          name: RndCnstLfsrSeed
          desc: Compile-time random bits for initial LFSR seed
          type: alert_handler_pkg::lfsr_seed_t
          randcount: 32
          randtype: data
          name_top: RndCnstAlertHandlerLfsrSeed
          default: 0x6eb2922b
          randwidth: 32
        }
        {
          name: RndCnstLfsrPerm
          desc: Compile-time random permutation for LFSR output
          type: alert_handler_pkg::lfsr_perm_t
          randcount: 32
          randtype: perm
          name_top: RndCnstAlertHandlerLfsrPerm
          default: 0x8ce0b2f58ac22443bf794b6be0981fbd9da15383
          randwidth: 160
        }
      ]
      template_type: alert_handler
    }
    {
      name: sram_ctrl_ret_aon
      type: sram_ctrl
      base_addrs:
      {
        regs:
        {
          hart: 0x30500000
        }
        ram:
        {
          hart: 0x30600000
        }
      }
      memory:
      {
        ram:
        {
          label: ram_ret_aon
          swaccess: rw
          data_intg_passthru: "true"
          exec: True
          byte_write: True
          size: 0x1000
        }
      }
      param_list:
      [
        {
          name: RndCnstSramKey
          desc: Compile-time random reset value for SRAM scrambling key.
          type: otp_ctrl_pkg::sram_key_t
          randcount: 128
          randtype: data
          name_top: RndCnstSramCtrlRetAonSramKey
          default: 0xa6102ac52c3399f857ba1734be633e47
          randwidth: 128
        }
        {
          name: RndCnstSramNonce
          desc: Compile-time random reset value for SRAM scrambling nonce.
          type: otp_ctrl_pkg::sram_nonce_t
          randcount: 128
          randtype: data
          name_top: RndCnstSramCtrlRetAonSramNonce
          default: 0x91548eb20a6ea1d8935f5076924e87e9
          randwidth: 128
        }
        {
          name: RndCnstLfsrSeed
          desc: Compile-time random bits for initial LFSR seed
          type: sram_ctrl_pkg::lfsr_seed_t
          randcount: 64
          randtype: data
          name_top: RndCnstSramCtrlRetAonLfsrSeed
          default: 0xfc4e7c979c1cfe52
          randwidth: 64
        }
        {
          name: RndCnstLfsrPerm
          desc: Compile-time random permutation for LFSR output
          type: sram_ctrl_pkg::lfsr_perm_t
          randcount: 64
          randtype: perm
          name_top: RndCnstSramCtrlRetAonLfsrPerm
          default: 0xfab70f7d84c5065028211c35cc4e563761c3bbd7b886aa54c7ac927670bb90a8d98afff4f0919ab0e4209ad5773176cb
          randwidth: 384
        }
      ]
    }
    {
      name: aes
      type: aes
      base_addrs:
      {
        null:
        {
          hart: 0x21100000
        }
      }
      memory: {}
      param_list:
      [
        {
          name: RndCnstClearingLfsrSeed
          desc: Default seed of the PRNG used for register clearing.
          type: aes_pkg::clearing_lfsr_seed_t
          randcount: 64
          randtype: data
          name_top: RndCnstAesClearingLfsrSeed
          default: 0x8a8115aaa655a738
          randwidth: 64
        }
        {
          name: RndCnstClearingLfsrPerm
          desc: Permutation applied to the LFSR of the PRNG used for clearing.
          type: aes_pkg::clearing_lfsr_perm_t
          randcount: 64
          randtype: perm
          name_top: RndCnstAesClearingLfsrPerm
          default: 0xb968e420a2d2178cccf25c6ddb49d7df01b5e8e6d47b96a2360c9f64056cfa9ecf87f99c26a1c1a040980dd45342bbfd
          randwidth: 384
        }
        {
          name: RndCnstClearingSharePerm
          desc: Permutation applied to the clearing PRNG output for clearing the second share of registers.
          type: aes_pkg::clearing_lfsr_perm_t
          randcount: 64
          randtype: perm
          name_top: RndCnstAesClearingSharePerm
          default: 0x5aa62679a9f50b45ce2c4c32549e78062cefe94b1b4cac7d4370ff49f1f68641a5328b63ae001d14d73c211ecfb99a7e
          randwidth: 384
        }
        {
          name: RndCnstMaskingLfsrSeed
          desc: Default seed of the PRNG used for masking.
          type: aes_pkg::masking_lfsr_seed_t
          randcount: 288
          randtype: data
          name_top: RndCnstAesMaskingLfsrSeed
          default: 0xf4295565eacbab6e055182324f468874bd74c5ddd144efb2bf98a4bebf48300e66f46f65
          randwidth: 288
        }
        {
          name: RndCnstMaskingLfsrPerm
          desc: Permutation applied to the output of the PRNG used for masking.
          type: aes_pkg::masking_lfsr_perm_t
          randcount: 160
          randtype: perm
          name_top: RndCnstAesMaskingLfsrPerm
          default: 0x57a559807742b31385237451f9d2976970f126d6c4c474650547e915a4e10992357139f4a6f674071226288632e9b81777b034d87091c4f5d90952a59533b6a8a9c645c494b600619243a019e17580c276b428516840d5f350b899666808d44831556327f7893483f9a8b920e418628437c61008f3d2c2d1451751a307d79722126338c043e1869826e391b2f1e5e738e02705b0a203c0868343611651d9425
          randwidth: 1280
        }
      ]
    }
    {
      name: kmac
      type: kmac
      base_addrs:
      {
        null:
        {
          hart: 0x21120000
        }
      }
      memory: {}
      param_list:
      [
        {
          name: RndCnstLfsrSeed
          desc: Compile-time random data for PRNG default seed
          type: kmac_pkg::lfsr_seed_t
          randcount: 288
          randtype: data
          name_top: RndCnstKmacLfsrSeed
          default: 0xfa055c5c33de5f27d9886bff3f4d69c2a5db91e7b811f857d91132ec8c73793f384646cc
          randwidth: 288
        }
        {
          name: RndCnstLfsrPerm
          desc: Compile-time random permutation for PRNG output
          type: kmac_pkg::lfsr_perm_t
          randcount: 800
          randtype: perm
          name_top: RndCnstKmacLfsrPerm
          default: 0x25861076476ac8685e636c5ec645df74c3401c329c1925994239987c192936535861187c24510e7e8b713c24820b03b20c3771d1556d75af1452992bc2303866747c6f83a31e3a4b57207e58e247fd1486eb33396eb00b1a08b354202315ceb259396d7aa2a2c3ce790f09701285bd471882c260cb023d0e442238bd84b3d9babcfa8b9e7548be71020a68e4bf9169de89002460c04fae4ee3e6ad49e310849e0382e765b9089f375a5533e25004c30f8ad2aa9cb491b9509fb5d6542d827f89899f04527001a5417447a8518e1484cbfc8b04d2aa3d0587d619c9246cd748848097e339cdc5755901ce10a8276a061d17dbbc35037aae27a0c66a4ca350e1c7d1942a86402dcb2153028f5a750d1393e14476048c8a8c3d0bed10d60151a93925b83ad4d801cc76c4989c7f82cb2651126f08932c5a820a53948d9bdda058ed7bd6769d239b5b463da67a6d6214fda6e804b92c6f4da9e229092364c82865e83ba059055d801417c2c6f2fe846b5edbeee493a38332ee7b9af3fe7f1d2c7b19cd811ca7ec422b12182ae71a9730449cbf562a7c545d8455606784aae97ab20daed009041c1dd28d311b6b49404d572533bd1c3826b309cbaa9a56fa5809aec1ae964f17929264559dec0a4c4c10883e5dbe58d5eccdb86ac4787b02539bc0bd158dcb320c95e712a69e3d30ea2044b820db550794525a871d9a6f7671ae1e7125b66e0a468b8cba6254b79569af9f90e211254471185e5bc62c32428716c92af48ae8c5a11f37ad92f1d40fede8ddfa2eea40189d1418b121ba7d315c515d681eb1917067a986212d1631a784a239d51446e61999f743118687790d7eaeda4ad8a184cd03101bbc48a8995aaa0f243e3eaea09b6cb76554829cc051f0f5505c7dafa3068b6b206618ae7e0df35c1e72699060d118dc1c1c14b697f36c089ab16bac570ad0c2d2978a8e39a093c60ab2a171bc9aa4998c45d7db0de273ea7799d703492ac287afc8e1e2a9482a23a9344ec274f4b69652f1969114c0c408af92e6c9f41c7923c0c5f7771d24253f8e833ba5a3af70594819988fe2516ab97191055e718fc1cacb55e078d23203e6578cf068599602fc0b585042d008ca09ea48855283483a889403ed725917766960a9b0a406609993a8d490b05b6b34c7bcdf2a399646888c065aae25634d8a36133676ca266923244a2324107eef00eab9864f70a90174ec5ae7b26c6e8a0f71d543c6eea80d784de058f6dd3887d475366c2443c49a68855781f58e695addb7ac5550aa7c6c922c5ec5b38dd21d5f2e48470c9152ad8b11063da944e23fa964da35fd6d47c0940bbd9c053a166620e900b8510d65f1593e0d56a08116c39c731044ed39d5fc1021e8ee30b50605306c06adf53c4bad5bf6065c
          randwidth: 8000
        }
        {
          name: RndCnstBufferLfsrSeed
          desc: Compile-time random data for PRNG buffer default seed
          type: kmac_pkg::buffer_lfsr_seed_t
          randcount: 800
          randtype: data
          name_top: RndCnstKmacBufferLfsrSeed
          default: 0x1a7af76f3cc7c36f4706f29bffd4d52c2087caae9d71da5bba6c103f8df24d25982112c63f37e231aa022f7760b920148a2364d338b0068e492d5dbf299b327848554bd78e6cb5b258d57a195a5e069fea708041bce69f5c7420202036921f4ed455d109
          randwidth: 800
        }
        {
          name: RndCnstMsgPerm
          desc: Compile-time random permutation for LFSR Message output
          type: kmac_pkg::msg_perm_t
          randcount: 64
          randtype: perm
          name_top: RndCnstKmacMsgPerm
          default: 0xe4e8045d83e3506778a4923ea15465b73c0cfe1c7c68393a896407032b3dd6f7f6ddc48aee6aab0ae4cbd019c579b64d
          randwidth: 384
        }
      ]
    }
    {
      name: otbn
      type: otbn
      base_addrs:
      {
        null:
        {
          hart: 0x21130000
        }
      }
      memory: {}
      param_list:
      [
        {
          name: RndCnstUrndPrngSeed
          desc: Default seed of the PRNG used for URND.
          type: otbn_pkg::urnd_prng_seed_t
          randcount: 256
          randtype: data
          name_top: RndCnstOtbnUrndPrngSeed
          default: 0x496afad34c8c5679382bbe582c34ea5f5d2852a07efa0e494aa9fe6d81a74772
          randwidth: 256
        }
        {
          name: RndCnstOtbnKey
          desc: Compile-time random reset value for IMem/DMem scrambling key.
          type: otp_ctrl_pkg::otbn_key_t
          randcount: 128
          randtype: data
          name_top: RndCnstOtbnOtbnKey
          default: 0xdb8abc5e3267aa5447191563a2d3c7b5
          randwidth: 128
        }
        {
          name: RndCnstOtbnNonce
          desc: Compile-time random reset value for IMem/DMem scrambling nonce.
          type: otp_ctrl_pkg::otbn_nonce_t
          randcount: 64
          randtype: data
          name_top: RndCnstOtbnOtbnNonce
          default: 0xda91f92d26603d71
          randwidth: 64
        }
      ]
    }
    {
      name: keymgr_dpe
      type: keymgr_dpe
      base_addrs:
      {
        null:
        {
          hart: 0x21140000
        }
      }
      memory: {}
      param_list:
      [
        {
          name: RndCnstLfsrSeed
          desc: Compile-time random bits for initial LFSR seed
          type: keymgr_pkg::lfsr_seed_t
          randcount: 64
          randtype: data
          name_top: RndCnstKeymgrDpeLfsrSeed
          default: 0x608d11dff2fe679e
          randwidth: 64
        }
        {
          name: RndCnstLfsrPerm
          desc: Compile-time random permutation for LFSR output
          type: keymgr_pkg::lfsr_perm_t
          randcount: 64
          randtype: perm
          name_top: RndCnstKeymgrDpeLfsrPerm
          default: 0xa48ad21aa7ee5daa00cff845d20b5d5768d341eca2601ec944bbecdf8eb10fed7c6e59d9f56e445301cd3cc2a608e91c
          randwidth: 384
        }
        {
          name: RndCnstRandPerm
          desc: Compile-time random permutation for entropy used in share overriding
          type: keymgr_pkg::rand_perm_t
          randcount: 32
          randtype: perm
          name_top: RndCnstKeymgrDpeRandPerm
          default: 0xf10a91502d7a31be7ccbacafdb4f23d458072a07
          randwidth: 160
        }
        {
          name: RndCnstRevisionSeed
          desc: Compile-time random bits for revision seed
          type: keymgr_pkg::seed_t
          randcount: 256
          randtype: data
          name_top: RndCnstKeymgrDpeRevisionSeed
          default: 0x242306dfdc4084cb3d4da21d163c0070993270a2d2a94b466a1d7641ecd34918
          randwidth: 256
        }
        {
          name: RndCnstSoftOutputSeed
          desc: Compile-time random bits for software generation seed
          type: keymgr_pkg::seed_t
          randcount: 256
          randtype: data
          name_top: RndCnstKeymgrDpeSoftOutputSeed
          default: 0xfe43e3db0b29736b86b8d691441fa5d2620e71b0bd784d8deb951e74c5b42413
          randwidth: 256
        }
        {
          name: RndCnstHardOutputSeed
          desc: Compile-time random bits for hardware generation seed
          type: keymgr_pkg::seed_t
          randcount: 256
          randtype: data
          name_top: RndCnstKeymgrDpeHardOutputSeed
          default: 0x77963dc7f7e11a33ed9ed3d7b32e6e9ec756eec0d713707398b3c4bf69f9b787
          randwidth: 256
        }
        {
          name: RndCnstAesSeed
          desc: Compile-time random bits for generation seed when aes destination selected
          type: keymgr_pkg::seed_t
          randcount: 256
          randtype: data
          name_top: RndCnstKeymgrDpeAesSeed
          default: 0x1af8bce26443c9c0c05cfcffae5b001e66f8b69d73dc5679c54eece993b065a
          randwidth: 256
        }
        {
          name: RndCnstKmacSeed
          desc: Compile-time random bits for generation seed when kmac destination selected
          type: keymgr_pkg::seed_t
          randcount: 256
          randtype: data
          name_top: RndCnstKeymgrDpeKmacSeed
          default: 0x5897ba86583cafcba5c198863ab538ed09efd6aa8778726fc008fdb91fe718cf
          randwidth: 256
        }
        {
          name: RndCnstOtbnSeed
          desc: Compile-time random bits for generation seed when otbn destination selected
          type: keymgr_pkg::seed_t
          randcount: 256
          randtype: data
          name_top: RndCnstKeymgrDpeOtbnSeed
          default: 0x787475f9b6c633de89cc3671e2380a788af2bd5c4331e3c2c30aa6c060577d3b
          randwidth: 256
        }
        {
          name: RndCnstNoneSeed
          desc: Compile-time random bits for generation seed when no destination selected
          type: keymgr_pkg::seed_t
          randcount: 256
          randtype: data
          name_top: RndCnstKeymgrDpeNoneSeed
          default: 0x699444600e43a5715f3e99a5fe4c782dec5de40f7f2eeef984bcb9f66378919f
          randwidth: 256
        }
      ]
    }
    {
      name: csrng
      type: csrng
      base_addrs:
      {
        null:
        {
          hart: 0x21150000
        }
      }
      memory: {}
      param_list:
      [
        {
          name: RndCnstCsKeymgrDivNonProduction
          desc: Compile-time random bits for csrng state group diversification value
          type: csrng_pkg::cs_keymgr_div_t
          randcount: 384
          randtype: data
          name_top: RndCnstCsrngCsKeymgrDivNonProduction
          default: 0xbe9783b33a85ac60a1b91abece848f9c9273044dad9dd329485e173010f2ce7bf2e71d2dc254a70469e764c65d17c25e
          randwidth: 384
        }
        {
          name: RndCnstCsKeymgrDivProduction
          desc: Compile-time random bits for csrng state group diversification value
          type: csrng_pkg::cs_keymgr_div_t
          randcount: 384
          randtype: data
          name_top: RndCnstCsrngCsKeymgrDivProduction
          default: 0x9c496f06e631daae3117edc7522e5b0e6aa034ddf160ff98e5916d6f44a718e526b69d6e575de83da8a33a86e08e65bc
          randwidth: 384
        }
      ]
    }
    {
      name: sram_ctrl_main
      type: sram_ctrl
      base_addrs:
      {
        regs:
        {
          hart: 0x211c0000
        }
        ram:
        {
          hart: 0x10000000
        }
      }
      memory:
      {
        ram:
        {
          label: ram_main
          swaccess: rw
          data_intg_passthru: "true"
          exec: True
          byte_write: True
          size: 0x10000
        }
      }
      param_list:
      [
        {
          name: RndCnstSramKey
          desc: Compile-time random reset value for SRAM scrambling key.
          type: otp_ctrl_pkg::sram_key_t
          randcount: 128
          randtype: data
          name_top: RndCnstSramCtrlMainSramKey
          default: 0xa8644f5ee8768ef3e4128c330a399544
          randwidth: 128
        }
        {
          name: RndCnstSramNonce
          desc: Compile-time random reset value for SRAM scrambling nonce.
          type: otp_ctrl_pkg::sram_nonce_t
          randcount: 128
          randtype: data
          name_top: RndCnstSramCtrlMainSramNonce
          default: 0x37a72f580014f8eb4afc697dcbd4904b
          randwidth: 128
        }
        {
          name: RndCnstLfsrSeed
          desc: Compile-time random bits for initial LFSR seed
          type: sram_ctrl_pkg::lfsr_seed_t
          randcount: 64
          randtype: data
          name_top: RndCnstSramCtrlMainLfsrSeed
          default: 0x71f3c4b9f5e99d8b
          randwidth: 64
        }
        {
          name: RndCnstLfsrPerm
          desc: Compile-time random permutation for LFSR output
          type: sram_ctrl_pkg::lfsr_perm_t
          randcount: 64
          randtype: perm
          name_top: RndCnstSramCtrlMainLfsrPerm
          default: 0x51848b093dbc3802ba063d2571f8598086e93d0cebb3fdefaa7f70a1e1895796b89038b15c5bbb45633e344766d6dc87
          randwidth: 384
        }
      ]
    }
    {
      name: sram_ctrl_mbox
      type: sram_ctrl
      base_addrs:
      {
        regs:
        {
          hart: 0x211d0000
        }
        ram:
        {
          hart: 0x11000000
        }
      }
      memory:
      {
        ram:
        {
          label: ram_mbox
          swaccess: rw
          data_intg_passthru: "true"
          exec: False
          byte_write: True
          size: 0x1000
        }
      }
      param_list:
      [
        {
          name: RndCnstSramKey
          desc: Compile-time random reset value for SRAM scrambling key.
          type: otp_ctrl_pkg::sram_key_t
          randcount: 128
          randtype: data
          name_top: RndCnstSramCtrlMboxSramKey
          default: 0x30ed9f924e9e46717a83c5159f938f5c
          randwidth: 128
        }
        {
          name: RndCnstSramNonce
          desc: Compile-time random reset value for SRAM scrambling nonce.
          type: otp_ctrl_pkg::sram_nonce_t
          randcount: 128
          randtype: data
          name_top: RndCnstSramCtrlMboxSramNonce
          default: 0x27bf3ebcb99fa1f48f1d4f94038cfa87
          randwidth: 128
        }
        {
          name: RndCnstLfsrSeed
          desc: Compile-time random bits for initial LFSR seed
          type: sram_ctrl_pkg::lfsr_seed_t
          randcount: 64
          randtype: data
          name_top: RndCnstSramCtrlMboxLfsrSeed
          default: 0xfa5e396be143c84
          randwidth: 64
        }
        {
          name: RndCnstLfsrPerm
          desc: Compile-time random permutation for LFSR output
          type: sram_ctrl_pkg::lfsr_perm_t
          randcount: 64
          randtype: perm
          name_top: RndCnstSramCtrlMboxLfsrPerm
          default: 0xc5fe8bd808c6473b7da9349c5b2905675781b947665e12a0ddbc03fc8602afe56fd0e9509e8e0768f244322b3bf0de69
          randwidth: 384
        }
      ]
    }
    {
      name: rom_ctrl0
      type: rom_ctrl
      base_addrs:
      {
        rom:
        {
          hart: 0x00008000
        }
        regs:
        {
          hart: 0x211e0000
        }
      }
      memory:
      {
        rom:
        {
          label: rom0
          swaccess: ro
          data_intg_passthru: True
          exec: True
          byte_write: False
          size: 0x8000
        }
      }
      param_list:
      [
        {
          name: RndCnstScrNonce
          desc: Fixed nonce used for address / data scrambling
          type: bit [63:0]
          randcount: 64
          randtype: data
          name_top: RndCnstRomCtrl0ScrNonce
          default: 0xdd0ee9b7c570caf8
          randwidth: 64
        }
        {
          name: RndCnstScrKey
          desc: Randomised constant used as a scrambling key for ROM data
          type: bit [127:0]
          randcount: 128
          randtype: data
          name_top: RndCnstRomCtrl0ScrKey
          default: 0xc9a2bb12853b8785cbc77f0ce1a68150
          randwidth: 128
        }
      ]
    }
    {
      name: rom_ctrl1
      type: rom_ctrl
      base_addrs:
      {
        rom:
        {
          hart: 0x00020000
        }
        regs:
        {
          hart: 0x211e1000
        }
      }
      memory:
      {
        rom:
        {
          label: rom1
          swaccess: ro
          data_intg_passthru: True
          exec: True
          byte_write: False
          size: 0x10000
        }
      }
      param_list:
      [
        {
          name: RndCnstScrNonce
          desc: Fixed nonce used for address / data scrambling
          type: bit [63:0]
          randcount: 64
          randtype: data
          name_top: RndCnstRomCtrl1ScrNonce
          default: 0xa2eb908932e470ee
          randwidth: 64
        }
        {
          name: RndCnstScrKey
          desc: Randomised constant used as a scrambling key for ROM data
          type: bit [127:0]
          randcount: 128
          randtype: data
          name_top: RndCnstRomCtrl1ScrKey
          default: 0x5a9b29bcd69d582277b1e64385a896e8
          randwidth: 128
        }
      ]
    }
    {
      name: rv_core_ibex
      type: rv_core_ibex
      base_addrs:
      {
        cfg:
        {
          hart: 0x211f0000
        }
      }
      memory: {}
      param_list:
      [
        {
          name: RndCnstLfsrSeed
          desc: Default seed of the PRNG used for random instructions.
          type: ibex_pkg::lfsr_seed_t
          randcount: 32
          randtype: data
          name_top: RndCnstRvCoreIbexLfsrSeed
          default: 0x17b8a5c9
          randwidth: 32
        }
        {
          name: RndCnstLfsrPerm
          desc: Permutation applied to the LFSR of the PRNG used for random instructions.
          type: ibex_pkg::lfsr_perm_t
          randcount: 32
          randtype: perm
          name_top: RndCnstRvCoreIbexLfsrPerm
          default: 0xd0072162d481726ddd6d7b909557bee067f8b087
          randwidth: 160
        }
        {
          name: RndCnstIbexKeyDefault
          desc: Default icache scrambling key
          type: logic [ibex_pkg::SCRAMBLE_KEY_W-1:0]
          randcount: 128
          randtype: data
          name_top: RndCnstRvCoreIbexIbexKeyDefault
          default: 0xed74bc3bb6e6cb822b506b6520fc39c7
          randwidth: 128
        }
        {
          name: RndCnstIbexNonceDefault
          desc: Default icache scrambling nonce
          type: logic [ibex_pkg::SCRAMBLE_NONCE_W-1:0]
          randcount: 64
          randtype: data
          name_top: RndCnstRvCoreIbexIbexNonceDefault
          default: 0xa2d127467a42c0e
          randwidth: 64
        }
      ]
      template_type: rv_core_ibex
    }
  ]
}
