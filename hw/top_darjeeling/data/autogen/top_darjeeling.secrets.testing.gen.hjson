// Copyright lowRISC contributors (OpenTitan project).
// Licensed under the Apache License, Version 2.0, see LICENSE for details.
// SPDX-License-Identifier: Apache-2.0
//
// ------------------- W A R N I N G: A U T O - G E N E R A T E D   C O D E !! -------------------//
// PLEASE DO NOT HAND-EDIT THIS FILE. IT HAS BEEN AUTO-GENERATED WITH THE FOLLOWING COMMAND:
// util/topgen.py -t hw/top_darjeeling/data/top_darjeeling.hjson \
//                -o hw/top_darjeeling/
{
  seed:
  {
    topgen_seed:
    {
      seed_mode: testing
      value: 54333785388384718741805333876851324744086233326576410510444272798345081543471
    }
    lc_ctrl_seed:
    {
      seed_mode: testing
      value: 112993084956605421905698540113828573267222507933600967535087940626766958652087
    }
    otp_img_seed:
    {
      seed_mode: testing
      value: 27979703506148085132361254668065047751677209319772630603289834031211820975395
    }
  }
  module:
  [
    {
      name: otp_ctrl
      type: otp_ctrl
      base_addrs:
      {
        core:
        {
          hart: 0x30130000
        }
      }
      memory: {}
      param_list:
      [
        {
          name: RndCnstLfsrSeed
          desc: Compile-time random bits for initial LFSR seed
          type: otp_ctrl_top_specific_pkg::lfsr_seed_t
          randcount: 40
          randtype: data
          name_top: RndCnstOtpCtrlLfsrSeed
          default: 0xd7595a4fe2
          randwidth: 40
        }
        {
          name: RndCnstLfsrPerm
          desc: Compile-time random permutation for LFSR output
          type: otp_ctrl_top_specific_pkg::lfsr_perm_t
          randcount: 40
          randtype: perm
          name_top: RndCnstOtpCtrlLfsrPerm
          default: 0x4633a584248631e4046160e70622571c08263d914870b2956da35d7d44e4
          randwidth: 240
        }
        {
          name: RndCnstScrmblKeyInit
          desc: Compile-time random permutation for scrambling key/nonce register reset value
          type: otp_ctrl_top_specific_pkg::scrmbl_key_init_t
          randcount: 256
          randtype: data
          name_top: RndCnstOtpCtrlScrmblKeyInit
          default: 0xc6af92400628db87e3122c8e7ab4b794c9fb8f1264e4c41cc56ad0fccde38a96
          randwidth: 256
        }
        {
          name: RndCnstScrmblKey0
          desc: Compile-time scrambling key
          type: otp_ctrl_top_specific_pkg::key_t
          randcount: 128
          randtype: extdata
          name_top: RndCnstOtpCtrlScrmblKey0
          default: 0xf0e2382e0ee44fa9895f24be4ac18e34
          randwidth: 128
        }
        {
          name: RndCnstScrmblKey1
          desc: Compile-time scrambling key
          type: otp_ctrl_top_specific_pkg::key_t
          randcount: 128
          randtype: extdata
          name_top: RndCnstOtpCtrlScrmblKey1
          default: 0x211e272867d8a5b28f524626bd2392b3
          randwidth: 128
        }
        {
          name: RndCnstScrmblKey2
          desc: Compile-time scrambling key
          type: otp_ctrl_top_specific_pkg::key_t
          randcount: 128
          randtype: extdata
          name_top: RndCnstOtpCtrlScrmblKey2
          default: 0x31e66b4701f65e59af83059cc1ba5509
          randwidth: 128
        }
        {
          name: RndCnstScrmblKey3
          desc: Compile-time scrambling key
          type: otp_ctrl_top_specific_pkg::key_t
          randcount: 128
          randtype: extdata
          name_top: RndCnstOtpCtrlScrmblKey3
          default: 0x12a874275ac734b93bf8f083466ef2f3
          randwidth: 128
        }
        {
          name: RndCnstScrmblKey4
          desc: Compile-time scrambling key
          type: otp_ctrl_top_specific_pkg::key_t
          randcount: 128
          randtype: extdata
          name_top: RndCnstOtpCtrlScrmblKey4
          default: 0xf076e0ba6366de585a1c750847905ca4
          randwidth: 128
        }
        {
          name: RndCnstScrmblKey5
          desc: Compile-time scrambling key
          type: otp_ctrl_top_specific_pkg::key_t
          randcount: 128
          randtype: extdata
          name_top: RndCnstOtpCtrlScrmblKey5
          default: 0x2d31b460654aea39a8764c3897d3b202
          randwidth: 128
        }
        {
          name: RndCnstDigestConst0
          desc: Compile-time digest const
          type: otp_ctrl_top_specific_pkg::digest_const_t
          randcount: 128
          randtype: extdata
          name_top: RndCnstOtpCtrlDigestConst0
          default: 0xfe81243c9287d208e65ed1a810ca3c84
          randwidth: 128
        }
        {
          name: RndCnstDigestConst1
          desc: Compile-time digest const
          type: otp_ctrl_top_specific_pkg::digest_const_t
          randcount: 128
          randtype: extdata
          name_top: RndCnstOtpCtrlDigestConst1
          default: 0x598afab911240c43dbb448f23bc47ea5
          randwidth: 128
        }
        {
          name: RndCnstDigestIV0
          desc: Compile-time digest initial vector
          type: otp_ctrl_top_specific_pkg::digest_iv_t
          randcount: 64
          randtype: extdata
          name_top: RndCnstOtpCtrlDigestIV0
          default: 0x699a4150668f160f
          randwidth: 64
        }
        {
          name: RndCnstDigestIV1
          desc: Compile-time digest initial vector
          type: otp_ctrl_top_specific_pkg::digest_iv_t
          randcount: 64
          randtype: extdata
          name_top: RndCnstOtpCtrlDigestIV1
          default: 0x6bae953b000abd46
          randwidth: 64
        }
        {
          name: RndCnstPartInvDefault
          desc: OTP invalid partition default for buffered partitions
          type: logic [163839:0]
          randcount: 163840
          randtype: extdata
          name_top: RndCnstOtpCtrlPartInvDefault
          default:
          [
            {
              size: 704
              items:
              [
                {
                  size: 320
                  inv_default: 1346938694073743506210604571907290247744495844309767318051901381616023841411277056210752640269890
                }
                {
                  size: 384
                  inv_default: 38159489859871528012014545775033726014562581088732829659171289668783823807118634623100944391765786463798185715886804
                }
              ]
            }
            {
              size: 640
              items:
              [
                {
                  size: 64
                  inv_default: 0
                }
                {
                  size: 64
                  inv_default: 5616004543374932184
                }
                {
                  size: 256
                  inv_default: 15262142047031988005251309748757925346903988807302050625537529218857981668357
                }
                {
                  size: 256
                  inv_default: 1203977166749760650602329107067535620483501281825550000960003188310369458025
                }
              ]
            }
            {
              size: 384
              items:
              [
                {
                  size: 64
                  inv_default: 0
                }
                {
                  size: 64
                  inv_default: 3695109256757431018
                }
                {
                  size: 256
                  inv_default: 10599371899915034057897987994560919318593524221583877200182626631097778048814
                }
              ]
            }
            {
              size: 1024
              items:
              [
                {
                  size: 64
                  inv_default: 0
                }
                {
                  size: 64
                  inv_default: 12211039200127545828
                }
                {
                  size: 256
                  inv_default: 618893265675549456377841011005023430960191591985442350756386031168057610184
                }
                {
                  size: 256
                  inv_default: 44801230425435186956258274366201864788170307061535737679846747097832992094144
                }
                {
                  size: 256
                  inv_default: 7902800436012805411294651361522722082033268323043717797799699848422947779140
                }
                {
                  size: 128
                  inv_default: 316928147852353239067110430966290084938
                }
              ]
            }
            {
              size: 256
              items:
              [
                {
                  size: 64
                  inv_default: 0
                }
                {
                  size: 64
                  inv_default: 12352438367519599259
                }
                {
                  size: 128
                  inv_default: 69863303690126452913563553037773258116
                }
              ]
            }
            {
              size: 384
              items:
              [
                {
                  size: 64
                  inv_default: 0
                }
                {
                  size: 64
                  inv_default: 13305491143858070289
                }
                {
                  size: 128
                  inv_default: 49828175274156913446118274758811504407
                }
                {
                  size: 128
                  inv_default: 73831901041976284457570874566171875578
                }
              ]
            }
            {
              size: 448
              items:
              [
                {
                  size: 64
                  inv_default: 0
                }
                {
                  size: 64
                  inv_default: 16511885176833319924
                }
                {
                  comment: unallocated space
                  size: 32
                  inv_default: 0
                }
                {
                  size: 256
                  inv_default: 113431299695871457810879678334836187339246742145836790997971409368629624091190
                }
                {
                  size: 32
                  inv_default: 0
                }
              ]
            }
            {
              size: 192
              items:
              [
                {
                  size: 64
                  inv_default: 0
                }
                {
                  size: 64
                  inv_default: 5761682008078860944
                }
                {
                  comment: unallocated space
                  size: 48
                  inv_default: 0
                }
                {
                  size: 8
                  inv_default: 105
                }
                {
                  size: 8
                  inv_default: 105
                }
              ]
            }
            {
              size: 384
              items:
              [
                {
                  size: 64
                  inv_default: 0
                }
                {
                  size: 64
                  inv_default: 15736866452214181854
                }
                {
                  size: 256
                  inv_default: 40089012069765872372199334980134859346700507666967123710614821720185978876307
                }
              ]
            }
            {
              size: 192
              items:
              [
                {
                  size: 64
                  inv_default: 0
                }
                {
                  size: 64
                  inv_default: 8803623895717951126
                }
                {
                  size: 64
                  inv_default: 3245135129763961982
                }
              ]
            }
            {
              size: 18368
              items:
              [
                {
                  size: 64
                  inv_default: 0
                }
                {
                  size: 18304
                  inv_default: 0
                }
              ]
            }
            {
              size: 33856
              items:
              [
                {
                  size: 64
                  inv_default: 497467941740258226
                }
                {
                  size: 30720
                  inv_default: 0
                }
                {
                  size: 3072
                  inv_default: 0
                }
              ]
            }
            {
              size: 3136
              items:
              [
                {
                  size: 64
                  inv_default: 15563155100447382093
                }
                {
                  size: 1024
                  inv_default: 0
                }
                {
                  size: 2048
                  inv_default: 0
                }
              ]
            }
            {
              size: 65664
              items:
              [
                {
                  size: 64
                  inv_default: 0
                }
                {
                  size: 64
                  inv_default: 7881896702500903297
                }
                {
                  size: 65536
                  inv_default: 0
                }
              ]
            }
            {
              size: 8256
              items:
              [
                {
                  size: 64
                  inv_default: 0
                }
                {
                  size: 8192
                  inv_default: 0
                }
              ]
            }
            {
              size: 1280
              items:
              [
                {
                  size: 64
                  inv_default: 0
                }
                {
                  size: 64
                  inv_default: 6314004083024320026
                }
                {
                  size: 512
                  inv_default: 0
                }
                {
                  size: 32
                  inv_default: 0
                }
                {
                  size: 32
                  inv_default: 0
                }
                {
                  size: 512
                  inv_default: 0
                }
                {
                  size: 32
                  inv_default: 0
                }
                {
                  size: 32
                  inv_default: 0
                }
              ]
            }
            {
              size: 1280
              items:
              [
                {
                  size: 64
                  inv_default: 0
                }
                {
                  size: 64
                  inv_default: 899833317950292790
                }
                {
                  size: 512
                  inv_default: 0
                }
                {
                  size: 32
                  inv_default: 0
                }
                {
                  size: 32
                  inv_default: 0
                }
                {
                  size: 512
                  inv_default: 0
                }
                {
                  size: 32
                  inv_default: 0
                }
                {
                  size: 32
                  inv_default: 0
                }
              ]
            }
            {
              size: 1280
              items:
              [
                {
                  size: 64
                  inv_default: 0
                }
                {
                  size: 64
                  inv_default: 6911337809181396458
                }
                {
                  size: 512
                  inv_default: 0
                }
                {
                  size: 32
                  inv_default: 0
                }
                {
                  size: 32
                  inv_default: 0
                }
                {
                  size: 512
                  inv_default: 0
                }
                {
                  size: 32
                  inv_default: 0
                }
                {
                  size: 32
                  inv_default: 0
                }
              ]
            }
            {
              size: 1280
              items:
              [
                {
                  size: 64
                  inv_default: 0
                }
                {
                  size: 64
                  inv_default: 13022557762012396181
                }
                {
                  size: 512
                  inv_default: 0
                }
                {
                  size: 32
                  inv_default: 0
                }
                {
                  size: 32
                  inv_default: 0
                }
                {
                  size: 512
                  inv_default: 0
                }
                {
                  size: 32
                  inv_default: 0
                }
                {
                  size: 32
                  inv_default: 0
                }
              ]
            }
            {
              size: 1280
              items:
              [
                {
                  size: 64
                  inv_default: 0
                }
                {
                  size: 64
                  inv_default: 13613404859098530722
                }
                {
                  size: 512
                  inv_default: 0
                }
                {
                  size: 32
                  inv_default: 0
                }
                {
                  size: 32
                  inv_default: 0
                }
                {
                  size: 512
                  inv_default: 0
                }
                {
                  size: 32
                  inv_default: 0
                }
                {
                  size: 32
                  inv_default: 0
                }
              ]
            }
            {
              size: 1280
              items:
              [
                {
                  size: 64
                  inv_default: 0
                }
                {
                  size: 64
                  inv_default: 8187068425930011275
                }
                {
                  size: 512
                  inv_default: 0
                }
                {
                  size: 32
                  inv_default: 0
                }
                {
                  size: 32
                  inv_default: 0
                }
                {
                  size: 512
                  inv_default: 0
                }
                {
                  size: 32
                  inv_default: 0
                }
                {
                  size: 32
                  inv_default: 0
                }
              ]
            }
            {
              size: 2432
              items:
              [
                {
                  size: 64
                  inv_default: 0
                }
                {
                  size: 64
                  inv_default: 3482940500857016635
                }
                {
                  size: 512
                  inv_default: 0
                }
                {
                  size: 32
                  inv_default: 0
                }
                {
                  size: 32
                  inv_default: 0
                }
                {
                  size: 512
                  inv_default: 0
                }
                {
                  size: 32
                  inv_default: 0
                }
                {
                  size: 32
                  inv_default: 0
                }
                {
                  size: 512
                  inv_default: 0
                }
                {
                  size: 32
                  inv_default: 0
                }
                {
                  size: 32
                  inv_default: 0
                }
                {
                  size: 512
                  inv_default: 0
                }
                {
                  size: 32
                  inv_default: 0
                }
                {
                  size: 32
                  inv_default: 0
                }
              ]
            }
            {
              size: 2880
              items:
              [
                {
                  size: 64
                  inv_default: 0
                }
                {
                  size: 64
                  inv_default: 9351492217133262506
                }
                {
                  size: 512
                  inv_default: 0
                }
                {
                  size: 512
                  inv_default: 0
                }
                {
                  size: 512
                  inv_default: 0
                }
                {
                  size: 32
                  inv_default: 0
                }
                {
                  size: 32
                  inv_default: 0
                }
                {
                  size: 512
                  inv_default: 0
                }
                {
                  size: 32
                  inv_default: 0
                }
                {
                  size: 32
                  inv_default: 0
                }
                {
                  size: 512
                  inv_default: 0
                }
                {
                  size: 32
                  inv_default: 0
                }
                {
                  size: 32
                  inv_default: 0
                }
              ]
            }
            {
              size: 6400
              items:
              [
                {
                  size: 64
                  inv_default: 0
                }
                {
                  size: 64
                  inv_default: 17244459621709600035
                }
                {
                  size: 128
                  inv_default: 0
                }
                {
                  size: 6144
                  inv_default: 0
                }
              ]
            }
            {
              size: 448
              items:
              [
                {
                  size: 64
                  inv_default: 0
                }
                {
                  size: 128
                  inv_default: 0
                }
                {
                  size: 128
                  inv_default: 0
                }
                {
                  size: 128
                  inv_default: 0
                }
              ]
            }
            {
              size: 7744
              items:
              [
                {
                  size: 64
                  inv_default: 0
                }
                {
                  size: 64
                  inv_default: 11795428238417073728
                }
                {
                  size: 32
                  inv_default: 0
                }
                {
                  size: 32
                  inv_default: 0
                }
                {
                  size: 32
                  inv_default: 0
                }
                {
                  size: 32
                  inv_default: 0
                }
                {
                  size: 32
                  inv_default: 0
                }
                {
                  size: 32
                  inv_default: 0
                }
                {
                  size: 32
                  inv_default: 0
                }
                {
                  size: 512
                  inv_default: 0
                }
                {
                  size: 128
                  inv_default: 0
                }
                {
                  size: 128
                  inv_default: 0
                }
                {
                  size: 224
                  inv_default: 0
                }
                {
                  size: 6304
                  inv_default: 0
                }
                {
                  size: 32
                  inv_default: 0
                }
                {
                  size: 32
                  inv_default: 0
                }
                {
                  size: 32
                  inv_default: 0
                }
              ]
            }
            {
              size: 1792
              items:
              [
                {
                  size: 64
                  inv_default: 0
                }
                {
                  size: 64
                  inv_default: 15422691379567619171
                }
                {
                  size: 32
                  inv_default: 0
                }
                {
                  size: 32
                  inv_default: 0
                }
                {
                  size: 32
                  inv_default: 0
                }
                {
                  size: 32
                  inv_default: 0
                }
                {
                  size: 32
                  inv_default: 0
                }
                {
                  size: 32
                  inv_default: 0
                }
                {
                  size: 32
                  inv_default: 0
                }
                {
                  size: 32
                  inv_default: 0
                }
                {
                  size: 32
                  inv_default: 0
                }
                {
                  size: 32
                  inv_default: 0
                }
                {
                  size: 32
                  inv_default: 0
                }
                {
                  size: 32
                  inv_default: 0
                }
                {
                  size: 32
                  inv_default: 0
                }
                {
                  size: 32
                  inv_default: 0
                }
                {
                  size: 32
                  inv_default: 0
                }
                {
                  size: 32
                  inv_default: 0
                }
                {
                  size: 32
                  inv_default: 0
                }
                {
                  size: 32
                  inv_default: 1768515945
                }
                {
                  size: 32
                  inv_default: 1768515945
                }
                {
                  size: 32
                  inv_default: 1768515945
                }
                {
                  size: 32
                  inv_default: 0
                }
                {
                  size: 992
                  inv_default: 0
                }
              ]
            }
            {
              size: 576
              items:
              [
                {
                  size: 64
                  inv_default: 0
                }
                {
                  size: 64
                  inv_default: 7205140007485333107
                }
                {
                  size: 448
                  inv_default: 0
                }
              ]
            }
          ]
          randwidth: 163840
        }
      ]
      template_type: otp_ctrl
      otp_mmap:
      {
        otp:
        {
          width: 2
          depth: 10240
          size: 20480
          addr_width: 14
          byte_addr_width: 15
        }
        scrambling:
        {
          key_size: 16
          iv_size: 8
          cnst_size: 16
          keys:
          [
            {
              name: Secret0Key
              value: 320189317542450762109386389465346444852
            }
            {
              name: Secret1Key
              value: 44021086981898178093354400183545467571
            }
            {
              name: Secret2Key
              value: 66328575914558343686655006108878001417
            }
            {
              name: Secret3Key
              value: 24800765673869174505990593035608453875
            }
            {
              name: Secret4Key
              value: 319631968044639741185501772586027080868
            }
            {
              name: Secret5Key
              value: 60073340827370232104489743368326459906
            }
          ]
          digests:
          [
            {
              name: CnstyDigest
              iv_value: 7609466333969716751
              cnst_value: 338294452189904115078342591035235515524
            }
            {
              name: SramDataKey
              iv_value: 7759303288642256198
              cnst_value: 119022913856251121374314477465064734373
            }
          ]
          num_keys: 6
          num_digests: 2
        }
        partitions:
        [
          {
            name: VENDOR_TEST
            variant: Unbuffered
            absorb: false
            secret: false
            sw_digest: true
            hw_digest: false
            write_lock: Digest
            read_lock: CSR
            key_sel: NoKey
            integrity: false
            bkout_type: false
            zeroizable: true
            skip_sw_header: true
            items:
            [
              {
                name: SCRATCH
                size: 56
                isdigest: false
                iszer: false
                ismubi: false
                iskeymgr_creator: false
                iskeymgr_owner: false
                absorb: false
                inv_default: 0
                offset: 0
              }
              {
                name: VENDOR_TEST_DIGEST
                size: 8
                offset: 56
                ismubi: false
                isdigest: true
                iszer: false
                inv_default: 7205140007485333107
                iskeymgr_creator: false
                iskeymgr_owner: false
              }
              {
                name: VENDOR_TEST_ZER
                size: 8
                offset: 64
                ismubi: false
                isdigest: false
                iszer: true
                inv_default: 0
                iskeymgr_creator: false
                iskeymgr_owner: false
              }
            ]
            desc:
              '''
              Vendor test partition.
              This is reserved for manufacturing smoke checks. The OTP wrapper
              control logic inside prim_otp is allowed to read/write to this
              region. ECC uncorrectable errors seen on the functional prim_otp
              interface will not lead to an alert for this partition.
              Instead, such errors will be reported as correctable ECC errors.
              '''
            iskeymgr_creator: false
            iskeymgr_owner: false
            size: 72
            offset: 0
          }
          {
            name: CREATOR_SW_CFG
            variant: Unbuffered
            absorb: false
            secret: false
            sw_digest: true
            hw_digest: false
            write_lock: Digest
            read_lock: CSR
            key_sel: NoKey
            integrity: true
            bkout_type: false
            zeroizable: true
            items:
            [
              {
                name: CREATOR_SW_CFG_AST_CFG
                size: 124
                desc:
                  '''
                  AST configuration data. These values get blindly copied to
                  the AST CSRs during ROM execution.
                  '''
                isdigest: false
                iszer: false
                ismubi: false
                iskeymgr_creator: false
                iskeymgr_owner: false
                absorb: false
                inv_default: 0
                offset: 72
              }
              {
                name: CREATOR_SW_CFG_AST_INIT_SIZE
                size: 4
                desc:
                  '''
                  Controls how many 32-bit words from the CREATOR_SW_CFG_AST_CFG item
                  get copied to the AST CSRs during ROM execution.
                  '''
                isdigest: false
                iszer: false
                ismubi: false
                iskeymgr_creator: false
                iskeymgr_owner: false
                absorb: false
                inv_default: 0
                offset: 196
              }
              {
                name: CREATOR_SW_CFG_ROM_SECURE_BOOT_EN
                size: 4
                ismubi: true
                inv_default: 1768515945
                desc:
                  '''
                  Secure boot chicken bit. Secure boot is enabled iff this is
                  set to kMultiBitBool32True. OTBN is not loaded with any code
                  for any other values.
                  '''
                isdigest: false
                iszer: false
                iskeymgr_creator: false
                iskeymgr_owner: false
                absorb: false
                offset: 200
              }
              {
                name: CREATOR_SW_CFG_ROM_SIGGEN_EN
                size: 4
                ismubi: true
                inv_default: 1768515945
                desc:
                  '''
                  Signature generation chicken bit. Asset signatures are
                  generated iff both this item and
                  CREATOR_SW_CFG_ROM_SECURE_BOOT_EN are set to
                  kMultiBitBool32True.
                  '''
                isdigest: false
                iszer: false
                iskeymgr_creator: false
                iskeymgr_owner: false
                absorb: false
                offset: 204
              }
              {
                name: CREATOR_SW_CFG_ROM_SIGVERIFY_EN
                size: 4
                ismubi: true
                inv_default: 1768515945
                desc:
                  '''
                  Signature verification chicken bit. Asset signatures are
                  verified iff this item, the CREATOR_SW_CFG_ROM_SECURE_BOOT_EN
                  and the CREATOR_SW_CFG_ROM_SIGGEN_EN ones are all set to
                  kMultiBitBool32True.
                  '''
                isdigest: false
                iszer: false
                iskeymgr_creator: false
                iskeymgr_owner: false
                absorb: false
                offset: 208
              }
              {
                name: CREATOR_SW_CFG_SIGVERIFY_SPX_EN
                size: 4
                desc:
                  '''
                  Controls whether or not SPHINCS+ signature verification will
                  be executed when the ROM attempts to boot the ROM_EXT.
                  A value of kSigverifySpxDisabledOtp disables SPHINCS+
                  signature verification, while all other values enable it.
                  Note, SPHINCS+ signature verification is always disabled in
                  TEST_UNLOCKED* LC states.
                  '''
                isdigest: false
                iszer: false
                ismubi: false
                iskeymgr_creator: false
                iskeymgr_owner: false
                absorb: false
                inv_default: 0
                offset: 212
              }
              {
                name: CREATOR_SW_CFG_RNG_EN
                size: 4
                desc:
                  '''
                  Whether or not to enable use of hardware generated entropy
                  (from the entropy complex via EDN) in the `rnd_uint32`
                  function. A value of kHardenedBoolTrue enables the use of
                  hardware generated entropy, while all other values disable.
                  '''
                isdigest: false
                iszer: false
                ismubi: false
                iskeymgr_creator: false
                iskeymgr_owner: false
                absorb: false
                inv_default: 0
                offset: 216
              }
              {
                name: CREATOR_SW_CFG_JITTER_EN
                size: 4
                desc:
                  '''
                  Whether or not to enable clock jitter. A value of
                  kMultiBitBool4False disables, while all other values enable.
                  '''
                isdigest: false
                iszer: false
                ismubi: false
                iskeymgr_creator: false
                iskeymgr_owner: false
                absorb: false
                inv_default: 0
                offset: 220
              }
              {
                name: CREATOR_SW_CFG_RET_RAM_RESET_MASK
                size: 4
                desc:
                  '''
                  Reset reason mask used to initialize (by overwriting with
                  random data) retention SRAM during ROM execution. A value of
                  0 only initializes retention SRAM on power-on-resets.See
                  rstmgr RESET_INFO CSR documentation for more details.
                  '''
                isdigest: false
                iszer: false
                ismubi: false
                iskeymgr_creator: false
                iskeymgr_owner: false
                absorb: false
                inv_default: 0
                offset: 224
              }
              {
                name: CREATOR_SW_CFG_CPUCTRL
                size: 4
                desc:
                  '''
                  Value to write to the Ibex CPUCTRL CSR during ROM execution.
                  This field controls settings such as ICACHE enablement. See
                  Ibex documentation for more information.
                  '''
                isdigest: false
                iszer: false
                ismubi: false
                iskeymgr_creator: false
                iskeymgr_owner: false
                absorb: false
                inv_default: 0
                offset: 228
              }
              {
                name: CREATOR_SW_CFG_RNG_REPCNT_THRESHOLDS
                size: 4
                isdigest: false
                iszer: false
                ismubi: false
                iskeymgr_creator: false
                iskeymgr_owner: false
                absorb: false
                inv_default: 0
                offset: 232
              }
              {
                name: CREATOR_SW_CFG_RNG_REPCNTS_THRESHOLDS
                size: 4
                isdigest: false
                iszer: false
                ismubi: false
                iskeymgr_creator: false
                iskeymgr_owner: false
                absorb: false
                inv_default: 0
                offset: 236
              }
              {
                name: CREATOR_SW_CFG_RNG_ADAPTP_HI_THRESHOLDS
                size: 4
                isdigest: false
                iszer: false
                ismubi: false
                iskeymgr_creator: false
                iskeymgr_owner: false
                absorb: false
                inv_default: 0
                offset: 240
              }
              {
                name: CREATOR_SW_CFG_RNG_ADAPTP_LO_THRESHOLDS
                size: 4
                isdigest: false
                iszer: false
                ismubi: false
                iskeymgr_creator: false
                iskeymgr_owner: false
                absorb: false
                inv_default: 0
                offset: 244
              }
              {
                name: CREATOR_SW_CFG_RNG_BUCKET_THRESHOLDS
                size: 4
                isdigest: false
                iszer: false
                ismubi: false
                iskeymgr_creator: false
                iskeymgr_owner: false
                absorb: false
                inv_default: 0
                offset: 248
              }
              {
                name: CREATOR_SW_CFG_RNG_MARKOV_HI_THRESHOLDS
                size: 4
                isdigest: false
                iszer: false
                ismubi: false
                iskeymgr_creator: false
                iskeymgr_owner: false
                absorb: false
                inv_default: 0
                offset: 252
              }
              {
                name: CREATOR_SW_CFG_RNG_MARKOV_LO_THRESHOLDS
                size: 4
                isdigest: false
                iszer: false
                ismubi: false
                iskeymgr_creator: false
                iskeymgr_owner: false
                absorb: false
                inv_default: 0
                offset: 256
              }
              {
                name: CREATOR_SW_CFG_RNG_EXTHT_HI_THRESHOLDS
                size: 4
                isdigest: false
                iszer: false
                ismubi: false
                iskeymgr_creator: false
                iskeymgr_owner: false
                absorb: false
                inv_default: 0
                offset: 260
              }
              {
                name: CREATOR_SW_CFG_RNG_EXTHT_LO_THRESHOLDS
                size: 4
                isdigest: false
                iszer: false
                ismubi: false
                iskeymgr_creator: false
                iskeymgr_owner: false
                absorb: false
                inv_default: 0
                offset: 264
              }
              {
                name: CREATOR_SW_CFG_RNG_ALERT_THRESHOLD
                size: 4
                isdigest: false
                iszer: false
                ismubi: false
                iskeymgr_creator: false
                iskeymgr_owner: false
                absorb: false
                inv_default: 0
                offset: 268
              }
              {
                name: CREATOR_SW_CFG_RNG_HEALTH_CONFIG_DIGEST
                size: 4
                isdigest: false
                iszer: false
                ismubi: false
                iskeymgr_creator: false
                iskeymgr_owner: false
                absorb: false
                inv_default: 0
                offset: 272
              }
              {
                name: CREATOR_SW_CFG_SRAM_KEY_RENEW_EN
                size: 4
                desc:
                  '''
                  Whether or not the ROM should request SRAM to be re-scrambled
                  with a new key on every boot. kHardenedBoolFalse disables,
                  while all other values enable.
                  '''
                isdigest: false
                iszer: false
                ismubi: false
                iskeymgr_creator: false
                iskeymgr_owner: false
                absorb: false
                inv_default: 0
                offset: 276
              }
              {
                name: CREATOR_SW_CFG_DIGEST
                size: 8
                offset: 280
                ismubi: false
                isdigest: true
                iszer: false
                inv_default: 15422691379567619171
                iskeymgr_creator: false
                iskeymgr_owner: false
              }
              {
                name: CREATOR_SW_CFG_ZER
                size: 8
                offset: 288
                ismubi: false
                isdigest: false
                iszer: true
                inv_default: 0
                iskeymgr_creator: false
                iskeymgr_owner: false
              }
            ]
            desc:
              '''
              Software configuration partition.
              This is for device-specific calibration data. For example, clock,
              LDO, RNG.
              '''
            iskeymgr_creator: false
            iskeymgr_owner: false
            size: 224
            offset: 72
          }
          {
            name: OWNER_SW_CFG
            variant: Unbuffered
            absorb: false
            secret: false
            sw_digest: true
            hw_digest: false
            write_lock: Digest
            read_lock: CSR
            key_sel: NoKey
            integrity: true
            bkout_type: false
            zeroizable: true
            items:
            [
              {
                name: OWNER_SW_CFG_ROM_ERROR_REPORTING
                size: 4
                desc:
                  '''
                  The shutdown error reporting verbosity used by the ROM.
                  Should be configured to one of several
                  `shutdown_error_redact_t` values. See
                  `sw/device/silicon_creator/lib/shutdown.h` for more details.
                  '''
                isdigest: false
                iszer: false
                ismubi: false
                iskeymgr_creator: false
                iskeymgr_owner: false
                absorb: false
                inv_default: 0
                offset: 296
              }
              {
                name: OWNER_SW_CFG_ROM_ALERT_CLASS_EN
                size: 4
                desc:
                  '''
                  A four byte packed field, where each byte controls whether
                  or not the ROM enables each alert class (A through D) of the
                  alert_handler. The byte-sized sub-fields are arranged from D
                  to A, MSB to LSB. Each byte should be set to an
                  `alert_enable_t` value accordingly. See the alert_handler
                  documentation for more details.
                  '''
                isdigest: false
                iszer: false
                ismubi: false
                iskeymgr_creator: false
                iskeymgr_owner: false
                absorb: false
                inv_default: 0
                offset: 300
              }
              {
                name: OWNER_SW_CFG_ROM_ALERT_ESCALATION
                size: 4
                desc:
                  '''
                  A four byte packed field, where each byte controls the
                  escalation configuration for each alert class (A through D)
                  of the alert_handler configured by the ROM. The byte-sized
                  sub-fields are arranged from D to A, MSB to LSB. Each byte
                  should be set to an `alert_escalate_t` value accordingly.
                  See the alert_handler documentation for more details.
                  '''
                isdigest: false
                iszer: false
                ismubi: false
                iskeymgr_creator: false
                iskeymgr_owner: false
                absorb: false
                inv_default: 0
                offset: 304
              }
              {
                name: OWNER_SW_CFG_ROM_ALERT_CLASSIFICATION
                size: 788
                desc:
                  '''
                  The alert classifications (A through D) for each alert
                  source of the alert_handler to be configured by the ROM. The
                  field consists of a contiguous 320-byte block, or 80 32-bit
                  words. The four bytes in each word encode the configuration
                  of a single alert source across four lifecycle states, in
                  order from LSB to MSB: PROD, PROD_END, DEV, and RMA. Each
                  byte should be set to an `alert_class_t` value accordingly.
                  The order of the 197 32-bit words, from LSB to MSB can be
                  found in the DARJEELING_ALERTS list in
                  `hw/top_darjeeling/data/autogen/defs.bzl`.
                  See the alert_handler documentation for more details.
                  '''
                isdigest: false
                iszer: false
                ismubi: false
                iskeymgr_creator: false
                iskeymgr_owner: false
                absorb: false
                inv_default: 0
                offset: 308
              }
              {
                name: OWNER_SW_CFG_ROM_LOCAL_ALERT_CLASSIFICATION
                size: 28
                desc:
                  '''
                  Same as the `OWNER_SW_CFG_ROM_ALERT_CLASSIFICATION` field,
                  except these configuration correspond to the local alert
                  sources found in the `DARJEELING_LOC_ALERTS list in
                  `rules/const.bzl`.
                  '''
                isdigest: false
                iszer: false
                ismubi: false
                iskeymgr_creator: false
                iskeymgr_owner: false
                absorb: false
                inv_default: 0
                offset: 1096
              }
              {
                name: OWNER_SW_CFG_ROM_ALERT_ACCUM_THRESH
                size: 16
                desc:
                  '''
                  The alert accumulation threshold values for each alert class
                  (A through D) of the alert_handler to be configured by the
                  ROM. This field consists of four 32-bit words encoding the
                  accumulation thresholds for each alert class A through D
                  arranged LSW to MSW. See the alert_handler documentation for
                  more details.
                  '''
                isdigest: false
                iszer: false
                ismubi: false
                iskeymgr_creator: false
                iskeymgr_owner: false
                absorb: false
                inv_default: 0
                offset: 1124
              }
              {
                name: OWNER_SW_CFG_ROM_ALERT_TIMEOUT_CYCLES
                size: 16
                desc:
                  '''
                  Same as the `OWNER_SW_CFG_ROM_ALERT_ACCUM_THRESH` field,
                  except each value corresponds to the interrupt timeout
                  configuration of an alert class.
                  '''
                isdigest: false
                iszer: false
                ismubi: false
                iskeymgr_creator: false
                iskeymgr_owner: false
                absorb: false
                inv_default: 0
                offset: 1140
              }
              {
                name: OWNER_SW_CFG_ROM_ALERT_PHASE_CYCLES
                size: 64
                desc:
                  '''
                  The alert escalation phase durations, measured in clock
                  cycles, the ROM will configure the four alert phases for
                  each alert class of the alert_handler. This field consists
                  of a contiguous 64-byte block, or an array of four 128-bit
                  fields. Each 128-bit sub-field encodes four 32-bit words that
                  contain the alert phase cycle count configurations for alert
                  escalation phases 0 to 3, from LSW to MSW. Each 128-bit
                  sub-field is contains all configurations for a single alert
                  class, arranged from class A to D, from LS to MS. For
                  example, the cycle durations of each escalation phase in
                  this field should be configured as such, from LSB to MSB:
                  <classA,phase0>...<classA,phase3>...<classD,phase0>...
                  <classD,phase3>. See the alert_handler documentation for
                  more details.
                  '''
                isdigest: false
                iszer: false
                ismubi: false
                iskeymgr_creator: false
                iskeymgr_owner: false
                absorb: false
                inv_default: 0
                offset: 1156
              }
              {
                name: OWNER_SW_CFG_ROM_ALERT_DIGEST_PROD
                size: 4
                desc:
                  '''
                  The expected CRC32 digest over all of the alert_handler
                  configurations set up by the ROM for a device operating in
                  the PROD LC state. The ROM reads this field and checks it
                  against a digest it computes over the alert_handler
                  configuration it programmed. This field is expected to be
                  automatically computed by the `otp_alert_digest()` Bazel
                  rule. See the `alert_config_crc32()` function in the
                  SiliconCreator alert_handler driver for more details on what
                  configurations are included in this digest.
                  '''
                isdigest: false
                iszer: false
                ismubi: false
                iskeymgr_creator: false
                iskeymgr_owner: false
                absorb: false
                inv_default: 0
                offset: 1220
              }
              {
                name: OWNER_SW_CFG_ROM_ALERT_DIGEST_PROD_END
                size: 4
                desc:
                  '''
                  Same as the `OWNER_SW_CFG_ROM_ALERT_DIGEST_PROD` field,
                  except the expected digest is for chips operating in the
                  PROD_END LC state.
                  '''
                isdigest: false
                iszer: false
                ismubi: false
                iskeymgr_creator: false
                iskeymgr_owner: false
                absorb: false
                inv_default: 0
                offset: 1224
              }
              {
                name: OWNER_SW_CFG_ROM_ALERT_DIGEST_DEV
                size: 4
                desc:
                  '''
                  Same as the `OWNER_SW_CFG_ROM_ALERT_DIGEST_PROD` field,
                  except the expected digest is for chips operating in the
                  DEV LC state.
                  '''
                isdigest: false
                iszer: false
                ismubi: false
                iskeymgr_creator: false
                iskeymgr_owner: false
                absorb: false
                inv_default: 0
                offset: 1228
              }
              {
                name: OWNER_SW_CFG_ROM_ALERT_DIGEST_RMA
                size: 4
                desc:
                  '''
                  Same as the `OWNER_SW_CFG_ROM_ALERT_DIGEST_PROD` field,
                  except the expected digest is for chips operating in the
                  RMA LC state.
                  '''
                isdigest: false
                iszer: false
                ismubi: false
                iskeymgr_creator: false
                iskeymgr_owner: false
                absorb: false
                inv_default: 0
                offset: 1232
              }
              {
                name: OWNER_SW_CFG_ROM_WATCHDOG_BITE_THRESHOLD_CYCLES
                size: 4
                desc: Watchdog timer bite threshold (in cycles) configured by the ROM.
                isdigest: false
                iszer: false
                ismubi: false
                iskeymgr_creator: false
                iskeymgr_owner: false
                absorb: false
                inv_default: 0
                offset: 1236
              }
              {
                name: OWNER_SW_CFG_ROM_KEYMGR_OTP_MEAS_EN
                size: 4
                desc:
                  '''
                  Whether or not to configure the attestation SW binding CSRs
                  of the keymgr with the value of the measurement of the OTP
                  CreatorSwCfg, OwnerSwCfg, and secure boot key integrity digest.
                  A value of kHardenedBoolTrue uses the ROM computed OTP
                  measurements.
                  '''
                isdigest: false
                iszer: false
                ismubi: false
                iskeymgr_creator: false
                iskeymgr_owner: false
                absorb: false
                inv_default: 0
                offset: 1240
              }
              {
                name: OWNER_SW_CFG_ROM_RSTMGR_INFO_EN
                size: 4
                desc:
                  '''
                  A two byte packed word that indicates the expected rstmgr
                  alert and CPU info dump enable states, configured in the
                  rstmgr's ALERT_INFO_CTRL and CPU_INFO_CTRL CSRs respectively.
                  The expected format of this fields is
                  {0,0,kHardenedBool*,kHardenedBool*}, read MSB to LSB, where
                  the left most kHardenedBool* entry indicates the expected
                  enablement state of the ALERT_INFO_CTRL, and the right most
                  indicates the enablement state of the CPU_INFO_CTRL. Since
                  the ROM expects both to be disabled upon handing over
                  execution control to the ROM_EXT, this entire OTP field
                  **should be left unprovisioned, or set to all 0**.
                  '''
                isdigest: false
                iszer: false
                ismubi: false
                iskeymgr_creator: false
                iskeymgr_owner: false
                absorb: false
                inv_default: 0
                offset: 1244
              }
              {
                name: OWNER_SW_CFG_DIGEST
                size: 8
                offset: 1248
                ismubi: false
                isdigest: true
                iszer: false
                inv_default: 11795428238417073728
                iskeymgr_creator: false
                iskeymgr_owner: false
              }
              {
                name: OWNER_SW_CFG_ZER
                size: 8
                offset: 1256
                ismubi: false
                isdigest: false
                iszer: true
                inv_default: 0
                iskeymgr_creator: false
                iskeymgr_owner: false
              }
            ]
            desc:
              '''
              Software configuration partition.
              This contains data that changes software behavior in the ROM, for
              example enabling defensive features in ROM or selecting failure
              modes if verification fails.
              '''
            iskeymgr_creator: false
            iskeymgr_owner: false
            size: 968
            offset: 296
          }
          {
            name: OWNERSHIP_SLOT_STATE
            variant: Unbuffered
            absorb: false
            secret: false
            sw_digest: false
            hw_digest: false
            write_lock: None
            read_lock: CSR
            key_sel: NoKey
            integrity: true
            bkout_type: false
            zeroizable: true
            items:
            [
              {
                name: OWNERSHIP_SLOT_STATE_ROT_OWNER_AUTH
                size: 16
                desc:
                  '''
                  RoT Owner Ownership transfer state management
                  OWNERSHIP_ST_RAW:       ownership not yet claimed (factory default)
                  OWNERSHIP_ST_LOCKED0:   first ownership slot claimed
                  OWNERSHIP_ST_RELEASED0: first ownership slot released (assets have been cleared, ready to xfer)
                  OWNERSHIP_ST_LOCKED1:   second ownership slot claimed
                  OWNERSHIP_ST_SCRAPPED:  scrap state - terminal
                  '''
                isdigest: false
                iszer: false
                ismubi: false
                iskeymgr_creator: false
                iskeymgr_owner: false
                absorb: false
                inv_default: 0
                offset: 1264
              }
              {
                name: OWNERSHIP_SLOT_STATE_PLAT_INTEG_AUTH
                size: 16
                desc:
                  '''
                  Platform Integrator Ownership transfer state management
                  OWNERSHIP_ST_RAW:       ownership not yet claimed (factory default)
                  OWNERSHIP_ST_LOCKED0:   first ownership slot claimed
                  OWNERSHIP_ST_RELEASED0: first ownership slot released (assets have been cleared, ready to xfer)
                  OWNERSHIP_ST_LOCKED1:   second ownership slot claimed
                  OWNERSHIP_ST_SCRAPPED:  scrap state - terminal
                  '''
                isdigest: false
                iszer: false
                ismubi: false
                iskeymgr_creator: false
                iskeymgr_owner: false
                absorb: false
                inv_default: 0
                offset: 1280
              }
              {
                name: OWNERSHIP_SLOT_STATE_PLAT_OWNER_AUTH
                size: 16
                desc:
                  '''
                  Platform Owner Ownership transfer state management
                  OWNERSHIP_ST_RAW:       ownership not yet claimed (factory default)
                  OWNERSHIP_ST_LOCKED0:   first ownership slot claimed
                  OWNERSHIP_ST_RELEASED0: first ownership slot released (assets have been cleared, ready to xfer)
                  OWNERSHIP_ST_LOCKED1:   second ownership slot claimed
                  OWNERSHIP_ST_RELEASED1: second ownership slot released (assets have been cleared, ready to xfer)
                  OWNERSHIP_ST_LOCKED2:   third ownership slot claimed
                  OWNERSHIP_ST_RELEASED2: third ownership slot released (assets have been cleared, ready to xfer)
                  OWNERSHIP_ST_LOCKED3:   fourth ownership slot claimed
                  OWNERSHIP_ST_SCRAPPED:  scrap state - terminal
                  '''
                isdigest: false
                iszer: false
                ismubi: false
                iskeymgr_creator: false
                iskeymgr_owner: false
                absorb: false
                inv_default: 0
                offset: 1296
              }
              {
                name: OWNERSHIP_SLOT_STATE_ZER
                size: 8
                offset: 1312
                ismubi: false
                isdigest: false
                iszer: true
                inv_default: 0
                iskeymgr_creator: false
                iskeymgr_owner: false
              }
            ]
            desc:
              '''
              SW managed asset ownership states partition.

              Multi-bit enable value for the tracking the asset ownership states.
              Note that the states can be written multiple times in a device lifetime.
              The values to be written are engineered in the same way as the LC_CTRL
              state encoding words so that the ECC encoding remains valid even after
              updating the values.

              The constants can be found in the lc_ctrl_state_pkg.sv package.

              The programming order has to adhere to:

              OWNERSHIP_ST_RAW (factory all-zero state) ->
              OWNERSHIP_ST_LOCKED0 ->
              OWNERSHIP_ST_RELEASED0 ->
              ...
              OWNERSHIP_ST_SCRAPPED

              Note that if there are less than 4 slots available the higher slot states
              become logically equivalent to OWNERSHIP_SCRAPPED (firmware has to handle
              this correctly).
              '''
            iskeymgr_creator: false
            iskeymgr_owner: false
            size: 56
            offset: 1264
          }
          {
            name: ROT_CREATOR_IDENTITY
            variant: Unbuffered
            absorb: false
            secret: false
            sw_digest: true
            hw_digest: false
            write_lock: Digest
            read_lock: CSR
            key_sel: NoKey
            integrity: true
            bkout_type: false
            zeroizable: true
            items:
            [
              {
                name: ROT_CREATOR_IDENTITY_CERT
                size: 768
                desc:
                  '''
                  RoT Device Identity Certificate endorsed by the Silicon Creator stable PKI (off device).
                  It is expected to be provisioned at Factory Testing (FT) stage when LC = DEV or PROD.
                  Provisioning happens through a secured channel between the DUT and the HSM, i.e. the key
                  is protected against supply-chain and manufacturing attacks.
                  '''
                isdigest: false
                iszer: false
                ismubi: false
                iskeymgr_creator: false
                iskeymgr_owner: false
                absorb: false
                inv_default: 0
                offset: 1320
              }
              {
                name: ROT_CREATOR_IDENTITY_CERT_CMAC
                size: 16
                desc: A Cipher-based MAC for the RoT Device Identity Certificate.
                isdigest: false
                iszer: false
                ismubi: false
                iskeymgr_creator: false
                iskeymgr_owner: false
                absorb: false
                inv_default: 0
                offset: 2088
              }
              {
                name: ROT_CREATOR_IDENTITY_DIGEST
                size: 8
                offset: 2104
                ismubi: false
                isdigest: true
                iszer: false
                inv_default: 17244459621709600035
                iskeymgr_creator: false
                iskeymgr_owner: false
              }
              {
                name: ROT_CREATOR_IDENTITY_ZER
                size: 8
                offset: 2112
                ismubi: false
                isdigest: false
                iszer: true
                inv_default: 0
                iskeymgr_creator: false
                iskeymgr_owner: false
              }
            ]
            desc: Software managed partition for the RoT Creator identity.
            iskeymgr_creator: false
            iskeymgr_owner: false
            size: 800
            offset: 1320
          }
          {
            name: ROT_OWNER_AUTH_SLOT0
            variant: Unbuffered
            absorb: false
            secret: false
            sw_digest: true
            hw_digest: false
            write_lock: Digest
            read_lock: CSR
            key_sel: NoKey
            integrity: true
            bkout_type: false
            zeroizable: true
            items:
            [
              {
                name: ROT_OWNER_AUTH_SLOT0_NON_RAW_MFW_CODESIGN_KEY_TYPE
                size: 4
                desc:
                  '''
                  Key usage type. One of the following 32-bit values defined
                  by the sigverify API:
                  - kSigverifyKeyTypeTest for manufacturing, testing and RMA keys.
                  Keys of this type can be used only in TEST_UNLOCKED* and RMA life
                  cycle states.
                  - kSigverifyKeyTypeProd for production keys.
                  Keys of this type can be used in all operational life cycle states, i.e.
                  states in which CPU execution is enabled.
                  - kSigverifyKeyTypeDev for development keys.
                  Keys of this type can be used only in the DEV life cycle state.
                  '''
                isdigest: false
                iszer: false
                ismubi: false
                iskeymgr_creator: false
                iskeymgr_owner: false
                absorb: false
                inv_default: 0
                offset: 2120
              }
              {
                name: ROT_OWNER_AUTH_SLOT0_NON_RAW_MFW_CODESIGN_KEY_ROLE
                size: 4
                desc:
                  '''
                  Key role that describes the kind of assets a key could sign.
                  This must be set to the `kSigverifyKeyRoleBootstrapFirmwareSigning` 32-bit
                  value as defined by the sigverify API.
                  '''
                isdigest: false
                iszer: false
                ismubi: false
                iskeymgr_creator: false
                iskeymgr_owner: false
                absorb: false
                inv_default: 0
                offset: 2124
              }
              {
                name: ROT_OWNER_AUTH_SLOT0_NON_RAW_MFW_CODESIGN_KEY
                size: 64
                desc:
                  '''
                  Public Key used to verify manufacturing and debug firmware images.
                  Key Type: ECC NIST-P256 Curve.
                  It is expected to be provisioned at Final Test (FT) stage when LC = TEST_UNLOCKED.
                  Together with the ROM2_PATCH_SIGVERIFY_KEY and KEYMANIFEST_KEY keys, and their
                  associated device ID and metadata (stored in resp. KEY_DEVICE_ID and KEY_METADATA),
                  this key is signed with a Silicon Creator endorsed ECDSA P-256 key in order to protect
                  it from supply-chain and manufacturing attacks.
                  '''
                isdigest: false
                iszer: false
                ismubi: false
                iskeymgr_creator: false
                iskeymgr_owner: false
                absorb: false
                inv_default: 0
                offset: 2128
              }
              {
                name: ROT_OWNER_AUTH_SLOT0_ROM2_PATCH_SIGVERIFY_KEY_TYPE
                size: 4
                desc:
                  '''
                  Key usage type. One of the following 32-bit values defined
                  by the sigverify API:
                  - kSigverifyKeyTypeTest for manufacturing, testing and RMA keys.
                  Keys of this type can be used only in TEST_UNLOCKED* and RMA life
                  cycle states.
                  - kSigverifyKeyTypeProd for production keys.
                  Keys of this type can be used in all operational life cycle states, i.e.
                  states in which CPU execution is enabled.
                  - kSigverifyKeyTypeDev for development keys.
                  Keys of this type can be used only in the DEV life cycle state.
                  '''
                isdigest: false
                iszer: false
                ismubi: false
                iskeymgr_creator: false
                iskeymgr_owner: false
                absorb: false
                inv_default: 0
                offset: 2192
              }
              {
                name: ROT_OWNER_AUTH_SLOT0_ROM2_PATCH_SIGVERIFY_KEY_ROLE
                size: 4
                desc:
                  '''
                  Key role that describes the kind of assets a key could sign.
                  This must be set to the `kSigverifyKeyRoleRomPatchSigning` 32-bit
                  value as defined by the sigverify API.
                  '''
                isdigest: false
                iszer: false
                ismubi: false
                iskeymgr_creator: false
                iskeymgr_owner: false
                absorb: false
                inv_default: 0
                offset: 2196
              }
              {
                name: ROT_OWNER_AUTH_SLOT0_ROM2_PATCH_SIGVERIFY_KEY
                size: 64
                desc:
                  '''
                  Public Key used to verify the ROM2 OTP based patch.
                  Key Type: ECC NIST-P256 Curve.
                  It is expected to be provisioned at Final Test (FT) stage when LC = TEST_UNLOCKED.
                  Together with the NON_RAW_MFW_CODESIGN_KEY and KEYMANIFEST_KEY keys, and their
                  associated device ID and metadata (stored in resp. KEY_DEVICE_ID and KEY_METADATA),
                  this key is signed with a Silicon Creator endorsed ECDSA P-256 key in order to protect
                  it from supply-chain and manufacturing attacks.
                  '''
                isdigest: false
                iszer: false
                ismubi: false
                iskeymgr_creator: false
                iskeymgr_owner: false
                absorb: false
                inv_default: 0
                offset: 2200
              }
              {
                name: ROT_OWNER_AUTH_SLOT0_KEYMANIFEST_KEY_TYPE
                size: 4
                desc:
                  '''
                  Key usage type. One of the following 32-bit values defined
                  by the sigverify API:
                  - kSigverifyKeyTypeTest for manufacturing, testing and RMA keys.
                  Keys of this type can be used only in TEST_UNLOCKED* and RMA life
                  cycle states.
                  - kSigverifyKeyTypeProd for production keys.
                  Keys of this type can be used in all operational life cycle states, i.e.
                  states in which CPU execution is enabled.
                  - kSigverifyKeyTypeDev for development keys.
                  Keys of this type can be used only in the DEV life cycle state.
                  '''
                isdigest: false
                iszer: false
                ismubi: false
                iskeymgr_creator: false
                iskeymgr_owner: false
                absorb: false
                inv_default: 0
                offset: 2264
              }
              {
                name: ROT_OWNER_AUTH_SLOT0_KEYMANIFEST_KEY_ROLE
                size: 4
                desc:
                  '''
                  Key role that describes the kind of assets a key could sign.
                  This must be set to the `kSigverifyKeyRoleKeyBundleSigning` 32-bit
                  value as defined by the sigverify API.
                  '''
                isdigest: false
                iszer: false
                ismubi: false
                iskeymgr_creator: false
                iskeymgr_owner: false
                absorb: false
                inv_default: 0
                offset: 2268
              }
              {
                name: ROT_OWNER_AUTH_SLOT0_KEYMANIFEST_KEY
                size: 64
                desc:
                  '''
                  Public Key used to verify the RoT Creator (a.k.a. Silicon Creator) Key Manifest.
                  Key Type: ECC NIST-P256 Curve.
                  Together with the ROM2_PATCH_SIGVERIFY_KEY and NON_RAW_MFW_CODESIGN_KEY keys, and their
                  associated device ID and metadata (stored in resp. KEY_DEVICE_ID and KEY_METADATA),
                  this key is signed with a Silicon Creator endorsed ECDSA P-256 key in order to protect
                  it from supply-chain and manufacturing attacks.
                  '''
                isdigest: false
                iszer: false
                ismubi: false
                iskeymgr_creator: false
                iskeymgr_owner: false
                absorb: false
                inv_default: 0
                offset: 2272
              }
              {
                name: ROT_OWNER_AUTH_SLOT0_KEY_BINDING
                size: 64
                desc:
                  '''
                  A key binding value used to bind the ROT_OWNER_AUTH_SLOT0 keys to a SKU.
                  This item must store a SKU specific payload known at FT, like for example a fused
                  product identitfier or a ROM constant. The base ROM must verify the authenticity of
                  the ROT_OWNER_AUTH_SLOT0 first and then match the KEY_BINDING via an inline ROM check
                  before it uses the keys provisioned in this partition.
                  '''
                isdigest: false
                iszer: false
                ismubi: false
                iskeymgr_creator: false
                iskeymgr_owner: false
                absorb: false
                inv_default: 0
                offset: 2336
              }
              {
                name: ROT_OWNER_AUTH_SLOT0_KEY_SIGNATURE
                size: 64
                desc:
                  '''
                  ECDSA P-256 signature of the NON_RAW_MFW_CODESIGN_KEY,
                  ROM2_PATCH_SIGVERIFY_KEY, KEYMANIFEST_KEY, KEY_BINDING items in this partition.
                  As those three keys are expected to be provisioned at Final Test (FT) stage when
                  LC = TEST_UNLOCKED, this signatures aims at protecting them from supply-chain and
                  manufacturing attacks.
                  ROM images must include the corresponding signing key in order to verify all three
                  signatures.
                  '''
                isdigest: false
                iszer: false
                ismubi: false
                iskeymgr_creator: false
                iskeymgr_owner: false
                absorb: false
                inv_default: 0
                offset: 2400
              }
              {
                name: ROT_OWNER_AUTH_SLOT0_DIGEST
                size: 8
                offset: 2464
                ismubi: false
                isdigest: true
                iszer: false
                inv_default: 9351492217133262506
                iskeymgr_creator: false
                iskeymgr_owner: false
              }
              {
                name: ROT_OWNER_AUTH_SLOT0_ZER
                size: 8
                offset: 2472
                ismubi: false
                isdigest: false
                iszer: true
                inv_default: 0
                iskeymgr_creator: false
                iskeymgr_owner: false
              }
            ]
            desc: Software managed partition for the first RoT Owner (a.k.a. RoT Creator) key manifest.
            iskeymgr_creator: false
            iskeymgr_owner: false
            size: 360
            offset: 2120
          }
          {
            name: ROT_OWNER_AUTH_SLOT1
            variant: Unbuffered
            absorb: false
            secret: false
            sw_digest: true
            hw_digest: false
            write_lock: Digest
            read_lock: CSR
            key_sel: NoKey
            integrity: true
            bkout_type: false
            zeroizable: true
            items:
            [
              {
                name: ROT_OWNER_AUTH_SLOT1_NON_RAW_MFW_CODESIGN_KEY_TYPE
                size: 4
                desc:
                  '''
                  Key usage type. One of the following 32-bit values defined
                  by the sigverify API:
                  - kSigverifyKeyTypeTest for manufacturing, testing and RMA keys.
                  Keys of this type can be used only in TEST_UNLOCKED* and RMA life
                  cycle states.
                  - kSigverifyKeyTypeProd for production keys.
                  Keys of this type can be used in all operational life cycle states, i.e.
                  states in which CPU execution is enabled.
                  - kSigverifyKeyTypeDev for development keys.
                  Keys of this type can be used only in the DEV life cycle state.
                  '''
                isdigest: false
                iszer: false
                ismubi: false
                iskeymgr_creator: false
                iskeymgr_owner: false
                absorb: false
                inv_default: 0
                offset: 2480
              }
              {
                name: ROT_OWNER_AUTH_SLOT1_NON_RAW_MFW_CODESIGN_KEY_ROLE
                size: 4
                desc:
                  '''
                  Key role that describes the kind of assets a key could sign.
                  This must be set to the `kSigverifyKeyRoleBootstrapFirmwareSigning` 32-bit
                  value as defined by the sigverify API.
                  '''
                isdigest: false
                iszer: false
                ismubi: false
                iskeymgr_creator: false
                iskeymgr_owner: false
                absorb: false
                inv_default: 0
                offset: 2484
              }
              {
                name: ROT_OWNER_AUTH_SLOT1_NON_RAW_MFW_CODESIGN_KEY
                size: 64
                desc:
                  '''
                  Public Key used to verify manufacturing and debug firmware images.
                  Key Type: ECC NIST-P256 Curve.
                  It is expected to be provisioned at Final Test (FT) stage when LC = TEST_UNLOCKED.
                  Together with the ROM2_PATCH_SIGVERIFY_KEY and KEYMANIFEST_KEY keys, and their
                  associated device ID and metadata (stored in resp. KEY_DEVICE_ID and KEY_METADATA),
                  this key is signed with a Silicon Creator endorsed ECDSA P-256 key in order to protect
                  it from supply-chain and manufacturing attacks.
                  '''
                isdigest: false
                iszer: false
                ismubi: false
                iskeymgr_creator: false
                iskeymgr_owner: false
                absorb: false
                inv_default: 0
                offset: 2488
              }
              {
                name: ROT_OWNER_AUTH_SLOT1_ROM2_PATCH_SIGVERIFY_KEY_TYPE
                size: 4
                desc:
                  '''
                  Key usage type. One of the following 32-bit values defined
                  by the sigverify API:
                  - kSigverifyKeyTypeTest for manufacturing, testing and RMA keys.
                  Keys of this type can be used only in TEST_UNLOCKED* and RMA life
                  cycle states.
                  - kSigverifyKeyTypeProd for production keys.
                  Keys of this type can be used in all operational life cycle states, i.e.
                  states in which CPU execution is enabled.
                  - kSigverifyKeyTypeDev for development keys.
                  Keys of this type can be used only in the DEV life cycle state.
                  '''
                isdigest: false
                iszer: false
                ismubi: false
                iskeymgr_creator: false
                iskeymgr_owner: false
                absorb: false
                inv_default: 0
                offset: 2552
              }
              {
                name: ROT_OWNER_AUTH_SLOT1_ROM2_PATCH_SIGVERIFY_KEY_ROLE
                size: 4
                desc:
                  '''
                  Key role that describes the kind of assets a key could sign.
                  This must be set to the `kSigverifyKeyRoleRomPatchSigning` 32-bit
                  value as defined by the sigverify API.
                  '''
                isdigest: false
                iszer: false
                ismubi: false
                iskeymgr_creator: false
                iskeymgr_owner: false
                absorb: false
                inv_default: 0
                offset: 2556
              }
              {
                name: ROT_OWNER_AUTH_SLOT1_ROM2_PATCH_SIGVERIFY_KEY
                size: 64
                desc:
                  '''
                  Public Key used to verify the ROM2 OTP based patch.
                  Key Type: ECC NIST-P256 Curve.
                  It is expected to be provisioned at Final Test (FT) stage when LC = TEST_UNLOCKED.
                  Together with the NON_RAW_MFW_CODESIGN_KEY and KEYMANIFEST_KEY keys, and their
                  associated device ID and metadata (stored in resp. KEY_DEVICE_ID and KEY_METADATA),
                  this key is signed with a Silicon Creator endorsed ECDSA P-256 key in order to protect
                  it from supply-chain and manufacturing attacks.
                  '''
                isdigest: false
                iszer: false
                ismubi: false
                iskeymgr_creator: false
                iskeymgr_owner: false
                absorb: false
                inv_default: 0
                offset: 2560
              }
              {
                name: ROT_OWNER_AUTH_SLOT1_KEYMANIFEST_KEY_TYPE
                size: 4
                desc:
                  '''
                  Key usage type. One of the following 32-bit values defined
                  by the sigverify API:
                  - kSigverifyKeyTypeTest for manufacturing, testing and RMA keys.
                  Keys of this type can be used only in TEST_UNLOCKED* and RMA life
                  cycle states.
                  - kSigverifyKeyTypeProd for production keys.
                  Keys of this type can be used in all operational life cycle states, i.e.
                  states in which CPU execution is enabled.
                  - kSigverifyKeyTypeDev for development keys.
                  Keys of this type can be used only in the DEV life cycle state.
                  '''
                isdigest: false
                iszer: false
                ismubi: false
                iskeymgr_creator: false
                iskeymgr_owner: false
                absorb: false
                inv_default: 0
                offset: 2624
              }
              {
                name: ROT_OWNER_AUTH_SLOT1_KEYMANIFEST_KEY_ROLE
                size: 4
                desc:
                  '''
                  Key role that describes the kind of assets a key could sign.
                  This must be set to the `kSigverifyKeyRoleKeyBundleSigning` 32-bit
                  value as defined by the sigverify API.
                  '''
                isdigest: false
                iszer: false
                ismubi: false
                iskeymgr_creator: false
                iskeymgr_owner: false
                absorb: false
                inv_default: 0
                offset: 2628
              }
              {
                name: ROT_OWNER_AUTH_SLOT1_KEYMANIFEST_KEY
                size: 64
                desc:
                  '''
                  Public Key used to verify the RoT Owner (a.k.a. Silicon Owner) Key Manifest.
                  Key Type: ECC NIST-P256 Curve.
                  It is expected to be provisioned as part of the RoT Owner intra-role ownership transfer
                  process, when LC = PROD.
                  Provisioning happens through an Ownership Claim operation, after the previous RoT
                  Owner completed a Relinquish operation.
                  '''
                isdigest: false
                iszer: false
                ismubi: false
                iskeymgr_creator: false
                iskeymgr_owner: false
                absorb: false
                inv_default: 0
                offset: 2632
              }
              {
                name: ROT_OWNER_AUTH_SLOT1_UNLOCK4XFER_KEY_TYPE
                size: 4
                desc:
                  '''
                  Key usage type. One of the following 32-bit values defined
                  by the sigverify API:
                  - kSigverifyKeyTypeTest for manufacturing, testing and RMA keys.
                  Keys of this type can be used only in TEST_UNLOCKED* and RMA life
                  cycle states.
                  - kSigverifyKeyTypeProd for production keys.
                  Keys of this type can be used in all operational life cycle states, i.e.
                  states in which CPU execution is enabled.
                  - kSigverifyKeyTypeDev for development keys.
                  Keys of this type can be used only in the DEV life cycle state.
                  '''
                isdigest: false
                iszer: false
                ismubi: false
                iskeymgr_creator: false
                iskeymgr_owner: false
                absorb: false
                inv_default: 0
                offset: 2696
              }
              {
                name: ROT_OWNER_AUTH_SLOT1_UNLOCK4XFER_KEY_ROLE
                size: 4
                desc:
                  '''
                  Key role that describes the kind of assets a key could sign.
                  This must be set to the `kSigverifyKeyRoleRelinquishOwnership` 32-bit
                  value as defined by the sigverify API.
                  '''
                isdigest: false
                iszer: false
                ismubi: false
                iskeymgr_creator: false
                iskeymgr_owner: false
                absorb: false
                inv_default: 0
                offset: 2700
              }
              {
                name: ROT_OWNER_AUTH_SLOT1_UNLOCK4XFER_KEY
                size: 64
                desc:
                  '''
                  Public Key used to verify the RoT Owner Unlock Ownership firmware image.
                  Key Type: ECC NIST-P256 Curve.
                  It is expected to be provisioned as part of the RoT Owner intra-role ownership transfer
                  process, when LC = PROD.
                  Provisioning happens through an Ownership Claim operation, after the previous RoT
                  Owner completed a Relinquish operation.
                  '''
                isdigest: false
                iszer: false
                ismubi: false
                iskeymgr_creator: false
                iskeymgr_owner: false
                absorb: false
                inv_default: 0
                offset: 2704
              }
              {
                name: ROT_OWNER_AUTH_SLOT1_DIGEST
                size: 8
                offset: 2768
                ismubi: false
                isdigest: true
                iszer: false
                inv_default: 3482940500857016635
                iskeymgr_creator: false
                iskeymgr_owner: false
              }
              {
                name: ROT_OWNER_AUTH_SLOT1_ZER
                size: 8
                offset: 2776
                ismubi: false
                isdigest: false
                iszer: true
                inv_default: 0
                iskeymgr_creator: false
                iskeymgr_owner: false
              }
            ]
            desc: Software managed RoT Owner slot 1 partition.
            iskeymgr_creator: false
            iskeymgr_owner: false
            size: 304
            offset: 2480
          }
          {
            name: PLAT_INTEG_AUTH_SLOT0
            variant: Unbuffered
            absorb: false
            secret: false
            sw_digest: true
            hw_digest: false
            write_lock: Digest
            read_lock: CSR
            key_sel: NoKey
            integrity: true
            bkout_type: false
            zeroizable: true
            items:
            [
              {
                name: PLAT_INTEG_AUTH_SLOT0_KEYMANIFEST_KEY_TYPE
                size: 4
                desc:
                  '''
                  Key usage type. One of the following 32-bit values defined
                  by the sigverify API:
                  - kSigverifyKeyTypeTest for manufacturing, testing and RMA keys.
                  Keys of this type can be used only in TEST_UNLOCKED* and RMA life
                  cycle states.
                  - kSigverifyKeyTypeProd for production keys.
                  Keys of this type can be used in all operational life cycle states, i.e.
                  states in which CPU execution is enabled.
                  - kSigverifyKeyTypeDev for development keys.
                  Keys of this type can be used only in the DEV life cycle state.
                  '''
                isdigest: false
                iszer: false
                ismubi: false
                iskeymgr_creator: false
                iskeymgr_owner: false
                absorb: false
                inv_default: 0
                offset: 2784
              }
              {
                name: PLAT_INTEG_AUTH_SLOT0_KEYMANIFEST_KEY_ROLE
                size: 4
                desc:
                  '''
                  Key role that describes the kind of assets a key could sign.
                  This must be set to the `kSigverifyKeyRoleKeyBundleSigning` 32-bit
                  value as defined by the sigverify API.
                  '''
                isdigest: false
                iszer: false
                ismubi: false
                iskeymgr_creator: false
                iskeymgr_owner: false
                absorb: false
                inv_default: 0
                offset: 2788
              }
              {
                name: PLAT_INTEG_AUTH_SLOT0_KEYMANIFEST_KEY
                size: 64
                desc:
                  '''
                  Public Key used to verify the Platform Integrator Key Manifest.
                  Key Type: ECC NIST-P256 Curve.
                  This should be provisioned during the Platform Integrator Activation process, at the Platform
                  Integrator's manufacturing facilities.
                  The initial Platform Integrator provisions its Key Manifest public key using the provisioning
                  boot service provided by the current RoT Owner.
                  '''
                isdigest: false
                iszer: false
                ismubi: false
                iskeymgr_creator: false
                iskeymgr_owner: false
                absorb: false
                inv_default: 0
                offset: 2792
              }
              {
                name: PLAT_INTEG_AUTH_SLOT0_UNLOCK4XFER_KEY_TYPE
                size: 4
                desc:
                  '''
                  Key usage type. One of the following 32-bit values defined
                  by the sigverify API:
                  - kSigverifyKeyTypeTest for manufacturing, testing and RMA keys.
                  Keys of this type can be used only in TEST_UNLOCKED* and RMA life
                  cycle states.
                  - kSigverifyKeyTypeProd for production keys.
                  Keys of this type can be used in all operational life cycle states, i.e.
                  states in which CPU execution is enabled.
                  - kSigverifyKeyTypeDev for development keys.
                  Keys of this type can be used only in the DEV life cycle state.
                  '''
                isdigest: false
                iszer: false
                ismubi: false
                iskeymgr_creator: false
                iskeymgr_owner: false
                absorb: false
                inv_default: 0
                offset: 2856
              }
              {
                name: PLAT_INTEG_AUTH_SLOT0_UNLOCK4XFER_KEY_ROLE
                size: 4
                desc:
                  '''
                  Key role that describes the kind of assets a key could sign.
                  This must be set to the `kSigverifyKeyRoleRelinquishOwnership` 32-bit
                  value as defined by the sigverify API.
                  '''
                isdigest: false
                iszer: false
                ismubi: false
                iskeymgr_creator: false
                iskeymgr_owner: false
                absorb: false
                inv_default: 0
                offset: 2860
              }
              {
                name: PLAT_INTEG_AUTH_SLOT0_UNLOCK4XFER_KEY
                size: 64
                desc:
                  '''
                  Public Key used to verify the Platform Integrator Unlock Ownership firmware image.
                  Key Type: ECC NIST-P256 Curve.
                  This should be provisioned during the Platform Integrator Activation process, at the Platform
                  Integrator's manufacturing facilities.
                  The initial Platform Integrator provisions its Key Manifest public key using the provisioning
                  boot service provided by the current RoT Owner.
                  '''
                isdigest: false
                iszer: false
                ismubi: false
                iskeymgr_creator: false
                iskeymgr_owner: false
                absorb: false
                inv_default: 0
                offset: 2864
              }
              {
                name: PLAT_INTEG_AUTH_SLOT0_DIGEST
                size: 8
                offset: 2928
                ismubi: false
                isdigest: true
                iszer: false
                inv_default: 8187068425930011275
                iskeymgr_creator: false
                iskeymgr_owner: false
              }
              {
                name: PLAT_INTEG_AUTH_SLOT0_ZER
                size: 8
                offset: 2936
                ismubi: false
                isdigest: false
                iszer: true
                inv_default: 0
                iskeymgr_creator: false
                iskeymgr_owner: false
              }
            ]
            desc: Software managed Platform Integrator slot 0 partition.
            iskeymgr_creator: false
            iskeymgr_owner: false
            size: 160
            offset: 2784
          }
          {
            name: PLAT_INTEG_AUTH_SLOT1
            variant: Unbuffered
            absorb: false
            secret: false
            sw_digest: true
            hw_digest: false
            write_lock: Digest
            read_lock: CSR
            key_sel: NoKey
            integrity: true
            bkout_type: false
            zeroizable: true
            items:
            [
              {
                name: PLAT_INTEG_AUTH_SLOT1_KEYMANIFEST_KEY_TYPE
                size: 4
                desc:
                  '''
                  Key usage type. One of the following 32-bit values defined
                  by the sigverify API:
                  - kSigverifyKeyTypeTest for manufacturing, testing and RMA keys.
                  Keys of this type can be used only in TEST_UNLOCKED* and RMA life
                  cycle states.
                  - kSigverifyKeyTypeProd for production keys.
                  Keys of this type can be used in all operational life cycle states, i.e.
                  states in which CPU execution is enabled.
                  - kSigverifyKeyTypeDev for development keys.
                  Keys of this type can be used only in the DEV life cycle state.
                  '''
                isdigest: false
                iszer: false
                ismubi: false
                iskeymgr_creator: false
                iskeymgr_owner: false
                absorb: false
                inv_default: 0
                offset: 2944
              }
              {
                name: PLAT_INTEG_AUTH_SLOT1_KEYMANIFEST_KEY_ROLE
                size: 4
                desc:
                  '''
                  Key role that describes the kind of assets a key could sign.
                  This must be set to the `kSigverifyKeyRoleKeyBundleSigning` 32-bit
                  value as defined by the sigverify API.
                  '''
                isdigest: false
                iszer: false
                ismubi: false
                iskeymgr_creator: false
                iskeymgr_owner: false
                absorb: false
                inv_default: 0
                offset: 2948
              }
              {
                name: PLAT_INTEG_AUTH_SLOT1_KEYMANIFEST_KEY
                size: 64
                desc:
                  '''
                  Public Key used to verify the Platform Integrator Key Manifest.
                  Key Type: ECC NIST-P256 Curve.
                  This should be provisioned during the Platform Integrator intra-role ownership transfer
                  process when the lifecycle state (LC) is PROD. Provisioning occurs via an Ownership Claim
                  operation after the previous Platform Integrator completes a Relinquish operation.
                  '''
                isdigest: false
                iszer: false
                ismubi: false
                iskeymgr_creator: false
                iskeymgr_owner: false
                absorb: false
                inv_default: 0
                offset: 2952
              }
              {
                name: PLAT_INTEG_AUTH_SLOT1_UNLOCK4XFER_KEY_TYPE
                size: 4
                desc:
                  '''
                  Key usage type. One of the following 32-bit values defined
                  by the sigverify API:
                  - kSigverifyKeyTypeTest for manufacturing, testing and RMA keys.
                  Keys of this type can be used only in TEST_UNLOCKED* and RMA life
                  cycle states.
                  - kSigverifyKeyTypeProd for production keys.
                  Keys of this type can be used in all operational life cycle states, i.e.
                  states in which CPU execution is enabled.
                  - kSigverifyKeyTypeDev for development keys.
                  Keys of this type can be used only in the DEV life cycle state.
                  '''
                isdigest: false
                iszer: false
                ismubi: false
                iskeymgr_creator: false
                iskeymgr_owner: false
                absorb: false
                inv_default: 0
                offset: 3016
              }
              {
                name: PLAT_INTEG_AUTH_SLOT1_UNLOCK4XFER_KEY_ROLE
                size: 4
                desc:
                  '''
                  Key role that describes the kind of assets a key could sign.
                  This must be set to the `kSigverifyKeyRoleRelinquishOwnership` 32-bit
                  value as defined by the sigverify API.
                  '''
                isdigest: false
                iszer: false
                ismubi: false
                iskeymgr_creator: false
                iskeymgr_owner: false
                absorb: false
                inv_default: 0
                offset: 3020
              }
              {
                name: PLAT_INTEG_AUTH_SLOT1_UNLOCK4XFER_KEY
                size: 64
                desc:
                  '''
                  Public Key used to verify the Platform Integrator Unlock Ownership firmware image
                  Key Type: ECC NIST-P256 Curve.
                  This should be provisioned during the Platform Integrator intra-role ownership transfer
                  process when the lifecycle state (LC) is PROD. Provisioning occurs via an Ownership Claim
                  operation after the previous Platform Integrator completes a Relinquish operation.
                  '''
                isdigest: false
                iszer: false
                ismubi: false
                iskeymgr_creator: false
                iskeymgr_owner: false
                absorb: false
                inv_default: 0
                offset: 3024
              }
              {
                name: PLAT_INTEG_AUTH_SLOT1_DIGEST
                size: 8
                offset: 3088
                ismubi: false
                isdigest: true
                iszer: false
                inv_default: 13613404859098530722
                iskeymgr_creator: false
                iskeymgr_owner: false
              }
              {
                name: PLAT_INTEG_AUTH_SLOT1_ZER
                size: 8
                offset: 3096
                ismubi: false
                isdigest: false
                iszer: true
                inv_default: 0
                iskeymgr_creator: false
                iskeymgr_owner: false
              }
            ]
            desc: Software managed Platform Integrator slot 1 partition.
            iskeymgr_creator: false
            iskeymgr_owner: false
            size: 160
            offset: 2944
          }
          {
            name: PLAT_OWNER_AUTH_SLOT0
            variant: Unbuffered
            absorb: false
            secret: false
            sw_digest: true
            hw_digest: false
            write_lock: Digest
            read_lock: CSR
            key_sel: NoKey
            integrity: true
            bkout_type: false
            zeroizable: true
            items:
            [
              {
                name: PLAT_OWNER_AUTH_SLOT0_KEYMANIFEST_KEY_TYPE
                size: 4
                desc:
                  '''
                  Key usage type. One of the following 32-bit values defined
                  by the sigverify API:
                  - kSigverifyKeyTypeTest for manufacturing, testing and RMA keys.
                  Keys of this type can be used only in TEST_UNLOCKED* and RMA life
                  cycle states.
                  - kSigverifyKeyTypeProd for production keys.
                  Keys of this type can be used in all operational life cycle states, i.e.
                  states in which CPU execution is enabled.
                  - kSigverifyKeyTypeDev for development keys.
                  Keys of this type can be used only in the DEV life cycle state.
                  '''
                isdigest: false
                iszer: false
                ismubi: false
                iskeymgr_creator: false
                iskeymgr_owner: false
                absorb: false
                inv_default: 0
                offset: 3104
              }
              {
                name: PLAT_OWNER_AUTH_SLOT0_KEYMANIFEST_KEY_ROLE
                size: 4
                desc:
                  '''
                  Key role that describes the kind of assets a key could sign.
                  This must be set to the `kSigverifyKeyRoleKeyBundleSigning` 32-bit
                  value as defined by the sigverify API.
                  '''
                isdigest: false
                iszer: false
                ismubi: false
                iskeymgr_creator: false
                iskeymgr_owner: false
                absorb: false
                inv_default: 0
                offset: 3108
              }
              {
                name: PLAT_OWNER_AUTH_SLOT0_KEYMANIFEST_KEY
                size: 64
                desc:
                  '''
                  Public Key used to verify the Platform Owner Key Manifest.
                  Key Type: ECC NIST-P256 Curve.
                  This should be provisioned during the Platform Owner Activation process, at the Platform
                  Owner's facilities.
                  The initial Platform Owner provisions its Key Manifest public key using the provisioning
                  boot service provided by the current RoT Owner.
                  '''
                isdigest: false
                iszer: false
                ismubi: false
                iskeymgr_creator: false
                iskeymgr_owner: false
                absorb: false
                inv_default: 0
                offset: 3112
              }
              {
                name: PLAT_OWNER_AUTH_SLOT0_UNLOCK4XFER_KEY_TYPE
                size: 4
                desc:
                  '''
                  Key usage type. One of the following 32-bit values defined
                  by the sigverify API:
                  - kSigverifyKeyTypeTest for manufacturing, testing and RMA keys.
                  Keys of this type can be used only in TEST_UNLOCKED* and RMA life
                  cycle states.
                  - kSigverifyKeyTypeProd for production keys.
                  Keys of this type can be used in all operational life cycle states, i.e.
                  states in which CPU execution is enabled.
                  - kSigverifyKeyTypeDev for development keys.
                  Keys of this type can be used only in the DEV life cycle state.
                  '''
                isdigest: false
                iszer: false
                ismubi: false
                iskeymgr_creator: false
                iskeymgr_owner: false
                absorb: false
                inv_default: 0
                offset: 3176
              }
              {
                name: PLAT_OWNER_AUTH_SLOT0_UNLOCK4XFER_KEY_ROLE
                size: 4
                desc:
                  '''
                  Key role that describes the kind of assets a key could sign.
                  This must be set to the `kSigverifyKeyRoleRelinquishOwnership` 32-bit
                  value as defined by the sigverify API.
                  '''
                isdigest: false
                iszer: false
                ismubi: false
                iskeymgr_creator: false
                iskeymgr_owner: false
                absorb: false
                inv_default: 0
                offset: 3180
              }
              {
                name: PLAT_OWNER_AUTH_SLOT0_UNLOCK4XFER_KEY
                size: 64
                desc:
                  '''
                  Public Key used to verify the Platform Owner Unlock Ownership firmware image.
                  Key Type: ECC NIST-P256 Curve.
                  This should be provisioned during the Platform Owner Activation process, at the Platform
                  Owner's facilities.
                  The initial Platform Owner provisions its Key Manifest public key using the provisioning
                  boot service provided by the current RoT Owner.
                  '''
                isdigest: false
                iszer: false
                ismubi: false
                iskeymgr_creator: false
                iskeymgr_owner: false
                absorb: false
                inv_default: 0
                offset: 3184
              }
              {
                name: PLAT_OWNER_AUTH_SLOT0_DIGEST
                size: 8
                offset: 3248
                ismubi: false
                isdigest: true
                iszer: false
                inv_default: 13022557762012396181
                iskeymgr_creator: false
                iskeymgr_owner: false
              }
              {
                name: PLAT_OWNER_AUTH_SLOT0_ZER
                size: 8
                offset: 3256
                ismubi: false
                isdigest: false
                iszer: true
                inv_default: 0
                iskeymgr_creator: false
                iskeymgr_owner: false
              }
            ]
            desc: Software managed Platform Owner slot 0 partition.
            iskeymgr_creator: false
            iskeymgr_owner: false
            size: 160
            offset: 3104
          }
          {
            name: PLAT_OWNER_AUTH_SLOT1
            variant: Unbuffered
            absorb: false
            secret: false
            sw_digest: true
            hw_digest: false
            write_lock: Digest
            read_lock: CSR
            key_sel: NoKey
            integrity: true
            bkout_type: false
            zeroizable: true
            items:
            [
              {
                name: PLAT_OWNER_AUTH_SLOT1_KEYMANIFEST_KEY_TYPE
                size: 4
                desc:
                  '''
                  Key usage type. One of the following 32-bit values defined
                  by the sigverify API:
                  - kSigverifyKeyTypeTest for manufacturing, testing and RMA keys.
                  Keys of this type can be used only in TEST_UNLOCKED* and RMA life
                  cycle states.
                  - kSigverifyKeyTypeProd for production keys.
                  Keys of this type can be used in all operational life cycle states, i.e.
                  states in which CPU execution is enabled.
                  - kSigverifyKeyTypeDev for development keys.
                  Keys of this type can be used only in the DEV life cycle state.
                  '''
                isdigest: false
                iszer: false
                ismubi: false
                iskeymgr_creator: false
                iskeymgr_owner: false
                absorb: false
                inv_default: 0
                offset: 3264
              }
              {
                name: PLAT_OWNER_AUTH_SLOT1_KEYMANIFEST_KEY_ROLE
                size: 4
                desc:
                  '''
                  Key role that describes the kind of assets a key could sign.
                  This must be set to the `kSigverifyKeyRoleKeyBundleSigning` 32-bit
                  value as defined by the sigverify API.
                  '''
                isdigest: false
                iszer: false
                ismubi: false
                iskeymgr_creator: false
                iskeymgr_owner: false
                absorb: false
                inv_default: 0
                offset: 3268
              }
              {
                name: PLAT_OWNER_AUTH_SLOT1_KEYMANIFEST_KEY
                size: 64
                desc:
                  '''
                  Public Key used to verify the Platform Owner Key Manifest.
                  Key Type: ECC NIST-P256 Curve.
                  This should be provisioned during the Platform Owner intra-role ownership transfer
                  process when the lifecycle state (LC) is PROD. Provisioning occurs via an Ownership Claim
                  operation after the previous Platform Owner completes a Relinquish operation.
                  '''
                isdigest: false
                iszer: false
                ismubi: false
                iskeymgr_creator: false
                iskeymgr_owner: false
                absorb: false
                inv_default: 0
                offset: 3272
              }
              {
                name: PLAT_OWNER_AUTH_SLOT1_UNLOCK4XFER_KEY_TYPE
                size: 4
                desc:
                  '''
                  Key usage type. One of the following 32-bit values defined
                  by the sigverify API:
                  - kSigverifyKeyTypeTest for manufacturing, testing and RMA keys.
                  Keys of this type can be used only in TEST_UNLOCKED* and RMA life
                  cycle states.
                  - kSigverifyKeyTypeProd for production keys.
                  Keys of this type can be used in all operational life cycle states, i.e.
                  states in which CPU execution is enabled.
                  - kSigverifyKeyTypeDev for development keys.
                  Keys of this type can be used only in the DEV life cycle state.
                  '''
                isdigest: false
                iszer: false
                ismubi: false
                iskeymgr_creator: false
                iskeymgr_owner: false
                absorb: false
                inv_default: 0
                offset: 3336
              }
              {
                name: PLAT_OWNER_AUTH_SLOT1_UNLOCK4XFER_KEY_ROLE
                size: 4
                desc:
                  '''
                  Key role that describes the kind of assets a key could sign.
                  This must be set to the `kSigverifyKeyRoleRelinquishOwnership` 32-bit
                  value as defined by the sigverify API.
                  '''
                isdigest: false
                iszer: false
                ismubi: false
                iskeymgr_creator: false
                iskeymgr_owner: false
                absorb: false
                inv_default: 0
                offset: 3340
              }
              {
                name: PLAT_OWNER_AUTH_SLOT1_UNLOCK4XFER_KEY
                size: 64
                desc:
                  '''
                  Public Key used to verify the Platform Owner Unlock Ownership firmware image.
                  Key Type: ECC NIST-P256 Curve.
                  This should be provisioned during the Platform Owner intra-role ownership transfer
                  process when the lifecycle state (LC) is PROD. Provisioning occurs via an Ownership Claim
                  operation after the previous Platform Owner completes a Relinquish operation.
                  '''
                isdigest: false
                iszer: false
                ismubi: false
                iskeymgr_creator: false
                iskeymgr_owner: false
                absorb: false
                inv_default: 0
                offset: 3344
              }
              {
                name: PLAT_OWNER_AUTH_SLOT1_DIGEST
                size: 8
                offset: 3408
                ismubi: false
                isdigest: true
                iszer: false
                inv_default: 6911337809181396458
                iskeymgr_creator: false
                iskeymgr_owner: false
              }
              {
                name: PLAT_OWNER_AUTH_SLOT1_ZER
                size: 8
                offset: 3416
                ismubi: false
                isdigest: false
                iszer: true
                inv_default: 0
                iskeymgr_creator: false
                iskeymgr_owner: false
              }
            ]
            desc: Software managed Platform Owner slot 1 partition.
            iskeymgr_creator: false
            iskeymgr_owner: false
            size: 160
            offset: 3264
          }
          {
            name: PLAT_OWNER_AUTH_SLOT2
            variant: Unbuffered
            absorb: false
            secret: false
            sw_digest: true
            hw_digest: false
            write_lock: Digest
            read_lock: CSR
            key_sel: NoKey
            integrity: true
            bkout_type: false
            zeroizable: true
            items:
            [
              {
                name: PLAT_OWNER_AUTH_SLOT2_KEYMANIFEST_KEY_TYPE
                size: 4
                desc:
                  '''
                  Key usage type. One of the following 32-bit values defined
                  by the sigverify API:
                  - kSigverifyKeyTypeTest for manufacturing, testing and RMA keys.
                  Keys of this type can be used only in TEST_UNLOCKED* and RMA life
                  cycle states.
                  - kSigverifyKeyTypeProd for production keys.
                  Keys of this type can be used in all operational life cycle states, i.e.
                  states in which CPU execution is enabled.
                  - kSigverifyKeyTypeDev for development keys.
                  Keys of this type can be used only in the DEV life cycle state.
                  '''
                isdigest: false
                iszer: false
                ismubi: false
                iskeymgr_creator: false
                iskeymgr_owner: false
                absorb: false
                inv_default: 0
                offset: 3424
              }
              {
                name: PLAT_OWNER_AUTH_SLOT2_KEYMANIFEST_KEY_ROLE
                size: 4
                desc:
                  '''
                  Key role that describes the kind of assets a key could sign.
                  This must be set to the `kSigverifyKeyRoleKeyBundleSigning` 32-bit
                  value as defined by the sigverify API.
                  '''
                isdigest: false
                iszer: false
                ismubi: false
                iskeymgr_creator: false
                iskeymgr_owner: false
                absorb: false
                inv_default: 0
                offset: 3428
              }
              {
                name: PLAT_OWNER_AUTH_SLOT2_KEYMANIFEST_KEY
                size: 64
                desc:
                  '''
                  Public Key used to verify the Platform Owner Key Manifest.
                  Key Type: ECC NIST-P256 Curve.
                  This should be provisioned during the Platform Owner intra-role ownership transfer
                  process when the lifecycle state (LC) is PROD. Provisioning occurs via an Ownership Claim
                  operation after the previous Platform Owner completes a Relinquish operation.
                  '''
                isdigest: false
                iszer: false
                ismubi: false
                iskeymgr_creator: false
                iskeymgr_owner: false
                absorb: false
                inv_default: 0
                offset: 3432
              }
              {
                name: PLAT_OWNER_AUTH_SLOT2_UNLOCK4XFER_KEY_TYPE
                size: 4
                desc:
                  '''
                  Key usage type. One of the following 32-bit values defined
                  by the sigverify API:
                  - kSigverifyKeyTypeTest for manufacturing, testing and RMA keys.
                  Keys of this type can be used only in TEST_UNLOCKED* and RMA life
                  cycle states.
                  - kSigverifyKeyTypeProd for production keys.
                  Keys of this type can be used in all operational life cycle states, i.e.
                  states in which CPU execution is enabled.
                  - kSigverifyKeyTypeDev for development keys.
                  Keys of this type can be used only in the DEV life cycle state.
                  '''
                isdigest: false
                iszer: false
                ismubi: false
                iskeymgr_creator: false
                iskeymgr_owner: false
                absorb: false
                inv_default: 0
                offset: 3496
              }
              {
                name: PLAT_OWNER_AUTH_SLOT2_UNLOCK4XFER_KEY_ROLE
                size: 4
                desc:
                  '''
                  Key role that describes the kind of assets a key could sign.
                  This must be set to the `kSigverifyKeyRoleRelinquishOwnership` 32-bit
                  value as defined by the sigverify API.
                  '''
                isdigest: false
                iszer: false
                ismubi: false
                iskeymgr_creator: false
                iskeymgr_owner: false
                absorb: false
                inv_default: 0
                offset: 3500
              }
              {
                name: PLAT_OWNER_AUTH_SLOT2_UNLOCK4XFER_KEY
                size: 64
                desc:
                  '''
                  Public Key used to verify the Platform Owner Unlock Ownership firmware image.
                  Key Type: ECC NIST-P256 Curve.
                  This should be provisioned during the Platform Owner intra-role ownership transfer
                  process when the lifecycle state (LC) is PROD. Provisioning occurs via an Ownership Claim
                  operation after the previous Platform Owner completes a Relinquish operation.
                  '''
                isdigest: false
                iszer: false
                ismubi: false
                iskeymgr_creator: false
                iskeymgr_owner: false
                absorb: false
                inv_default: 0
                offset: 3504
              }
              {
                name: PLAT_OWNER_AUTH_SLOT2_DIGEST
                size: 8
                offset: 3568
                ismubi: false
                isdigest: true
                iszer: false
                inv_default: 899833317950292790
                iskeymgr_creator: false
                iskeymgr_owner: false
              }
              {
                name: PLAT_OWNER_AUTH_SLOT2_ZER
                size: 8
                offset: 3576
                ismubi: false
                isdigest: false
                iszer: true
                inv_default: 0
                iskeymgr_creator: false
                iskeymgr_owner: false
              }
            ]
            desc: Software managed Platform Owner slot 2 partition.
            iskeymgr_creator: false
            iskeymgr_owner: false
            size: 160
            offset: 3424
          }
          {
            name: PLAT_OWNER_AUTH_SLOT3
            variant: Unbuffered
            absorb: false
            secret: false
            sw_digest: true
            hw_digest: false
            write_lock: Digest
            read_lock: CSR
            key_sel: NoKey
            integrity: true
            bkout_type: false
            zeroizable: true
            items:
            [
              {
                name: PLAT_OWNER_AUTH_SLOT3_KEYMANIFEST_KEY_TYPE
                size: 4
                desc:
                  '''
                  Key usage type. One of the following 32-bit values defined
                  by the sigverify API:
                  - kSigverifyKeyTypeTest for manufacturing, testing and RMA keys.
                  Keys of this type can be used only in TEST_UNLOCKED* and RMA life
                  cycle states.
                  - kSigverifyKeyTypeProd for production keys.
                  Keys of this type can be used in all operational life cycle states, i.e.
                  states in which CPU execution is enabled.
                  - kSigverifyKeyTypeDev for development keys.
                  Keys of this type can be used only in the DEV life cycle state.
                  '''
                isdigest: false
                iszer: false
                ismubi: false
                iskeymgr_creator: false
                iskeymgr_owner: false
                absorb: false
                inv_default: 0
                offset: 3584
              }
              {
                name: PLAT_OWNER_AUTH_SLOT3_KEYMANIFEST_KEY_ROLE
                size: 4
                desc:
                  '''
                  Key role that describes the kind of assets a key could sign.
                  This must be set to the `kSigverifyKeyRoleKeyBundleSigning` 32-bit
                  value as defined by the sigverify API.
                  '''
                isdigest: false
                iszer: false
                ismubi: false
                iskeymgr_creator: false
                iskeymgr_owner: false
                absorb: false
                inv_default: 0
                offset: 3588
              }
              {
                name: PLAT_OWNER_AUTH_SLOT3_KEYMANIFEST_KEY
                size: 64
                desc:
                  '''
                  Public Key used to verify the Platform Owner Key Manifest.
                  Key Type: ECC NIST-P256 Curve.
                  This should be provisioned during the Platform Owner intra-role ownership transfer
                  process when the lifecycle state (LC) is PROD. Provisioning occurs via an Ownership Claim
                  operation after the previous Platform Owner completes a Relinquish operation.
                  '''
                isdigest: false
                iszer: false
                ismubi: false
                iskeymgr_creator: false
                iskeymgr_owner: false
                absorb: false
                inv_default: 0
                offset: 3592
              }
              {
                name: PLAT_OWNER_AUTH_SLOT3_UNLOCK4XFER_KEY_TYPE
                size: 4
                desc:
                  '''
                  Key usage type. One of the following 32-bit values defined
                  by the sigverify API:
                  - kSigverifyKeyTypeTest for manufacturing, testing and RMA keys.
                  Keys of this type can be used only in TEST_UNLOCKED* and RMA life
                  cycle states.
                  - kSigverifyKeyTypeProd for production keys.
                  Keys of this type can be used in all operational life cycle states, i.e.
                  states in which CPU execution is enabled.
                  - kSigverifyKeyTypeDev for development keys.
                  Keys of this type can be used only in the DEV life cycle state.
                  '''
                isdigest: false
                iszer: false
                ismubi: false
                iskeymgr_creator: false
                iskeymgr_owner: false
                absorb: false
                inv_default: 0
                offset: 3656
              }
              {
                name: PLAT_OWNER_AUTH_SLOT3_UNLOCK4XFER_KEY_ROLE
                size: 4
                desc:
                  '''
                  Key role that describes the kind of assets a key could sign.
                  This must be set to the `kSigverifyKeyRoleRelinquishOwnership` 32-bit
                  value as defined by the sigverify API.
                  '''
                isdigest: false
                iszer: false
                ismubi: false
                iskeymgr_creator: false
                iskeymgr_owner: false
                absorb: false
                inv_default: 0
                offset: 3660
              }
              {
                name: PLAT_OWNER_AUTH_SLOT3_UNLOCK4XFER_KEY
                size: 64
                desc:
                  '''
                  Public Key used to verify the Platform Owner Unlock Ownership firmware image.
                  Key Type: ECC NIST-P256 Curve.
                  This should be provisioned during the Platform Owner intra-role ownership transfer
                  process when the lifecycle state (LC) is PROD. Provisioning occurs via an Ownership Claim
                  operation after the previous Platform Owner completes a Relinquish operation.
                  '''
                isdigest: false
                iszer: false
                ismubi: false
                iskeymgr_creator: false
                iskeymgr_owner: false
                absorb: false
                inv_default: 0
                offset: 3664
              }
              {
                name: PLAT_OWNER_AUTH_SLOT3_DIGEST
                size: 8
                offset: 3728
                ismubi: false
                isdigest: true
                iszer: false
                inv_default: 6314004083024320026
                iskeymgr_creator: false
                iskeymgr_owner: false
              }
              {
                name: PLAT_OWNER_AUTH_SLOT3_ZER
                size: 8
                offset: 3736
                ismubi: false
                isdigest: false
                iszer: true
                inv_default: 0
                iskeymgr_creator: false
                iskeymgr_owner: false
              }
            ]
            desc: Software managed Platform Owner slot 3 partition.
            iskeymgr_creator: false
            iskeymgr_owner: false
            size: 160
            offset: 3584
          }
          {
            name: EXT_NVM
            variant: Unbuffered
            absorb: false
            secret: false
            sw_digest: false
            hw_digest: false
            write_lock: None
            read_lock: CSR
            key_sel: NoKey
            integrity: false
            bkout_type: false
            zeroizable: true
            items:
            [
              {
                name: EXT_NVM_ANTIREPLAY_FRESHNESS_CNT
                size: 1024
                desc:
                  '''
                  Fully SW managed partition
                  1 bit (double bit allocated for redundancy - i.e. 2 physical bits for every logical bit) per day
                  assuming 10 year product lifecycle, allocating 8192 bits of freshness protection.
                  Implemented as thermometer encoding. Redundant bit programming & logical OR-ing managed by
                  software. Cannot be ECC protected since different bits in a fuse row are programmed at different times.
                  '''
                isdigest: false
                iszer: false
                ismubi: false
                iskeymgr_creator: false
                iskeymgr_owner: false
                absorb: false
                inv_default: 0
                offset: 3744
              }
              {
                name: EXT_NVM_ZER
                size: 8
                offset: 4768
                ismubi: false
                isdigest: false
                iszer: true
                inv_default: 0
                iskeymgr_creator: false
                iskeymgr_owner: false
              }
            ]
            desc: Anti-replay protection Strike Counters partition.
            iskeymgr_creator: false
            iskeymgr_owner: false
            size: 1032
            offset: 3744
          }
          {
            name: ROM_PATCH
            variant: Unbuffered
            absorb: false
            secret: false
            sw_digest: true
            hw_digest: false
            write_lock: Digest
            read_lock: CSR
            key_sel: NoKey
            integrity: true
            bkout_type: false
            zeroizable: true
            items:
            [
              {
                name: ROM_PATCH_DATA
                size: 8192
                desc:
                  '''
                  Fully SW managed partition.
                  ROM patch section for signed ROM patches.
                  Each patch contains a header, a signature, the patch match/redirect configuration and the actual patch code.
                  Please refer to the Darjeeling ROM boot & patching specification for more details.
                  '''
                isdigest: false
                iszer: false
                ismubi: false
                iskeymgr_creator: false
                iskeymgr_owner: false
                absorb: false
                inv_default: 0
                offset: 4776
              }
              {
                name: ROM_PATCH_DIGEST
                size: 8
                offset: 12968
                ismubi: false
                isdigest: true
                iszer: false
                inv_default: 7881896702500903297
                iskeymgr_creator: false
                iskeymgr_owner: false
              }
              {
                name: ROM_PATCH_ZER
                size: 8
                offset: 12976
                ismubi: false
                isdigest: false
                iszer: true
                inv_default: 0
                iskeymgr_creator: false
                iskeymgr_owner: false
              }
            ]
            desc: ROM Patch Code section. May contain multiple signed ROM2 patches.
            iskeymgr_creator: false
            iskeymgr_owner: false
            size: 8208
            offset: 4776
          }
          {
            name: SOC_FUSES_CP
            variant: Unbuffered
            absorb: false
            secret: false
            sw_digest: true
            hw_digest: false
            write_lock: Digest
            read_lock: CSR
            key_sel: NoKey
            integrity: true
            bkout_type: false
            items:
            [
              {
                name: SOC_FUSES_CP1_DATA
                size: 256
                isdigest: false
                iszer: false
                ismubi: false
                iskeymgr_creator: false
                iskeymgr_owner: false
                absorb: false
                inv_default: 0
                offset: 12984
              }
              {
                name: SOC_FUSES_CP2_DATA
                size: 128
                isdigest: false
                iszer: false
                ismubi: false
                iskeymgr_creator: false
                iskeymgr_owner: false
                absorb: false
                inv_default: 0
                offset: 13240
              }
              {
                name: SOC_FUSES_CP_DIGEST
                size: 8
                offset: 13368
                ismubi: false
                isdigest: true
                iszer: false
                inv_default: 15563155100447382093
                iskeymgr_creator: false
                iskeymgr_owner: false
              }
            ]
            desc: SoC fuses partition for the Chip Probe (CP) manufacturing stage.
            iskeymgr_creator: false
            iskeymgr_owner: false
            zeroizable: false
            size: 392
            offset: 12984
          }
          {
            name: SOC_FUSES_FT
            variant: Unbuffered
            absorb: false
            secret: false
            sw_digest: true
            hw_digest: false
            write_lock: Digest
            read_lock: CSR
            key_sel: NoKey
            integrity: true
            bkout_type: false
            items:
            [
              {
                name: SOC_FUSES_FT1_DATA
                size: 384
                isdigest: false
                iszer: false
                ismubi: false
                iskeymgr_creator: false
                iskeymgr_owner: false
                absorb: false
                inv_default: 0
                offset: 13376
              }
              {
                name: SOC_FUSES_FT2_DATA
                size: 3840
                isdigest: false
                iszer: false
                ismubi: false
                iskeymgr_creator: false
                iskeymgr_owner: false
                absorb: false
                inv_default: 0
                offset: 13760
              }
              {
                name: SOC_FUSES_FT_DIGEST
                size: 8
                offset: 17600
                ismubi: false
                isdigest: true
                iszer: false
                inv_default: 497467941740258226
                iskeymgr_creator: false
                iskeymgr_owner: false
              }
            ]
            desc: SoC fuses partition for the Factory Testing (FT) manufacturing stage.
            iskeymgr_creator: false
            iskeymgr_owner: false
            zeroizable: false
            size: 4232
            offset: 13376
          }
          {
            name: SCRATCH_FUSES
            variant: Unbuffered
            absorb: true
            secret: false
            sw_digest: false
            hw_digest: false
            write_lock: None
            read_lock: CSR
            key_sel: NoKey
            integrity: true
            bkout_type: false
            zeroizable: true
            items:
            [
              {
                name: SCRATCH_FUSES_DATA
                absorb: true
                desc:
                  '''
                  Fully SW managed partition.
                  Unstructured, single item partition for any RoT firmware (runtime,
                  bootstrap, manufacturing) to use and organize freely.
                  '''
                size: 2288
                isdigest: false
                iszer: false
                ismubi: false
                iskeymgr_creator: false
                iskeymgr_owner: false
                inv_default: 0
                offset: 17608
              }
              {
                name: SCRATCH_FUSES_ZER
                size: 8
                offset: 19896
                ismubi: false
                isdigest: false
                iszer: true
                inv_default: 0
                iskeymgr_creator: false
                iskeymgr_owner: false
              }
            ]
            desc: Unstructured scratch data partition.
            iskeymgr_creator: false
            iskeymgr_owner: false
            size: 2296
            offset: 17608
          }
          {
            name: CREATOR_MANUF_CFG
            variant: Buffered
            secret: true
            sw_digest: false
            hw_digest: true
            write_lock: Digest
            read_lock: None
            key_sel: Secret5Key
            integrity: true
            bkout_type: false
            zeroizable: true
            skip_sw_header: false
            items:
            [
              {
                name: MANUF_KEY_SALT
                size: 8
                inv_default: 3245135129763961982
                desc: Manufacturing key salt.
                isdigest: false
                iszer: false
                ismubi: false
                iskeymgr_creator: false
                iskeymgr_owner: false
                absorb: false
                offset: 19904
              }
              {
                name: CREATOR_MANUF_CFG_DIGEST
                size: 8
                offset: 19912
                ismubi: false
                isdigest: true
                iszer: false
                inv_default: 8803623895717951126
                iskeymgr_creator: false
                iskeymgr_owner: false
              }
              {
                name: CREATOR_MANUF_CFG_ZER
                size: 8
                offset: 19920
                ismubi: false
                isdigest: false
                iszer: true
                inv_default: 0
                iskeymgr_creator: false
                iskeymgr_owner: false
              }
            ]
            desc: Manufacturing key salt partition.
            absorb: false
            iskeymgr_creator: false
            iskeymgr_owner: false
            size: 24
            offset: 19904
          }
          {
            name: HW_CFG0
            variant: Buffered
            secret: false
            sw_digest: false
            hw_digest: true
            write_lock: Digest
            read_lock: None
            key_sel: NoKey
            integrity: true
            bkout_type: true
            zeroizable: true
            skip_sw_header: true
            items:
            [
              {
                name: DEVICE_ID
                size: 32
                inv_default: 40089012069765872372199334980134859346700507666967123710614821720185978876307
                desc:
                  '''
                  Unique device identifier that is always exposed through the
                  lifecycle JTAG tap. See OpenTitan documentation on Device
                  Identifiers.
                  '''
                isdigest: false
                iszer: false
                ismubi: false
                iskeymgr_creator: false
                iskeymgr_owner: false
                absorb: false
                offset: 19928
              }
              {
                name: HW_CFG0_DIGEST
                size: 8
                offset: 19960
                ismubi: false
                isdigest: true
                iszer: false
                inv_default: 15736866452214181854
                iskeymgr_creator: false
                iskeymgr_owner: false
              }
              {
                name: HW_CFG0_ZER
                size: 8
                offset: 19968
                ismubi: false
                isdigest: false
                iszer: true
                inv_default: 0
                iskeymgr_creator: false
                iskeymgr_owner: false
              }
            ]
            desc:
              '''
              Hardware configuration partition 0.
              This contains a device identifier.
              '''
            absorb: false
            iskeymgr_creator: false
            iskeymgr_owner: false
            size: 48
            offset: 19928
          }
          {
            name: HW_CFG1
            variant: Buffered
            secret: false
            sw_digest: false
            hw_digest: true
            write_lock: Digest
            read_lock: None
            key_sel: NoKey
            integrity: true
            bkout_type: true
            zeroizable: true
            skip_sw_header: true
            items:
            [
              {
                name: EN_CSRNG_SW_APP_READ
                size: 1
                ismubi: true
                inv_default: 105
                desc:
                  '''
                  Enablement of CSRNG software application interface. A
                  kMultiBitBool8True value enables, while all other values
                  disable. Enablement is required to extract output from
                  CSRNG via software.
                  '''
                isdigest: false
                iszer: false
                iskeymgr_creator: false
                iskeymgr_owner: false
                absorb: false
                offset: 19976
              }
              {
                name: EN_SRAM_IFETCH
                size: 1
                ismubi: true
                inv_default: 105
                desc:
                  '''
                  Enablement of execute from SRAM switch in the sram_ctrl (see
                  EXEC CSR). A kMultiBitBool8True value enables, while all
                  other values disable.
                  '''
                isdigest: false
                iszer: false
                iskeymgr_creator: false
                iskeymgr_owner: false
                absorb: false
                offset: 19977
              }
              {
                name: HW_CFG1_DIGEST
                size: 8
                offset: 19984
                ismubi: false
                isdigest: true
                iszer: false
                inv_default: 5761682008078860944
                iskeymgr_creator: false
                iskeymgr_owner: false
              }
              {
                name: HW_CFG1_ZER
                size: 8
                offset: 19992
                ismubi: false
                isdigest: false
                iszer: true
                inv_default: 0
                iskeymgr_creator: false
                iskeymgr_owner: false
              }
            ]
            desc:
              '''
              Hardware configuration partition 1.
              This contains several hardware feature switches.
              '''
            absorb: false
            iskeymgr_creator: false
            iskeymgr_owner: false
            size: 24
            offset: 19976
          }
          {
            name: HW_CFG2
            variant: Buffered
            secret: false
            sw_digest: false
            hw_digest: true
            write_lock: Digest
            read_lock: None
            key_sel: NoKey
            integrity: true
            bkout_type: true
            zeroizable: true
            items:
            [
              {
                name: SOC_DBG_STATE
                size: 4
                inv_default: 0
                desc:
                  '''
                  Multi-bit enable value for the SOC debug authorization.
                  SOC_DBG_STATE will be written twice in a device lifetime. The
                  values to be written are engineered in the same way as the LC_CTRL
                  state encoding words: the ECC encoding remains valid even after
                  writing the second value on top of the first.
                  The constants can be found in the lc_ctrl_state_pkg.sv package.
                  The programming order has to adhere to:
                  SOC_DBG_RAW -> SOC_DBG_PRE_PROD -> SOC_DBG_PROD.
                  Encoding:
                  SOC_DBG_RAW: this value is all-zeroes and will be the NOP state;
                  the LC controller will take precedence.
                  SOC_DBG_PRE_PROD: this is where the ROT will be in PROD state
                  but SOC will be in the pre-production unlock state
                  SOC_DBG_PROD: this is the state where the SOC moves to production,
                  and the challenge-response based authentication protocol is
                  required to unlock SOC debug features
                  '''
                isdigest: false
                iszer: false
                ismubi: false
                iskeymgr_creator: false
                iskeymgr_owner: false
                absorb: false
                offset: 20000
              }
              {
                name: MANUF_STATE
                size: 32
                inv_default: 113431299695871457810879678334836187339246742145836790997971409368629624091190
                desc: Field to capture the manufacturing state.
                isdigest: false
                iszer: false
                ismubi: false
                iskeymgr_creator: false
                iskeymgr_owner: false
                absorb: false
                offset: 20004
              }
              {
                name: HW_CFG2_DIGEST
                size: 8
                offset: 20040
                ismubi: false
                isdigest: true
                iszer: false
                inv_default: 16511885176833319924
                iskeymgr_creator: false
                iskeymgr_owner: false
              }
              {
                name: HW_CFG2_ZER
                size: 8
                offset: 20048
                ismubi: false
                isdigest: false
                iszer: true
                inv_default: 0
                iskeymgr_creator: false
                iskeymgr_owner: false
              }
            ]
            desc:
              '''
              Hardware configuration partition 2.
              This contains the SoC debug state and the manufacturing state.
              '''
            absorb: false
            iskeymgr_creator: false
            iskeymgr_owner: false
            size: 56
            offset: 20000
          }
          {
            name: SECRET0
            variant: Buffered
            secret: true
            sw_digest: false
            hw_digest: true
            write_lock: Digest
            read_lock: Digest
            key_sel: Secret0Key
            integrity: true
            bkout_type: false
            zeroizable: true
            skip_sw_header: true
            items:
            [
              {
                name: TEST_UNLOCK_TOKEN
                inv_default: 73831901041976284457570874566171875578
                size: 16
                isdigest: false
                iszer: false
                ismubi: false
                iskeymgr_creator: false
                iskeymgr_owner: false
                absorb: false
                offset: 20056
              }
              {
                name: TEST_EXIT_TOKEN
                inv_default: 49828175274156913446118274758811504407
                size: 16
                isdigest: false
                iszer: false
                ismubi: false
                iskeymgr_creator: false
                iskeymgr_owner: false
                absorb: false
                offset: 20072
              }
              {
                name: SECRET0_DIGEST
                size: 8
                offset: 20088
                ismubi: false
                isdigest: true
                iszer: false
                inv_default: 13305491143858070289
                iskeymgr_creator: false
                iskeymgr_owner: false
              }
              {
                name: SECRET0_ZER
                size: 8
                offset: 20096
                ismubi: false
                isdigest: false
                iszer: true
                inv_default: 0
                iskeymgr_creator: false
                iskeymgr_owner: false
              }
            ]
            desc:
              '''
              Secret partition 0.
              This contains TEST lifecycle unlock tokens.
              '''
            absorb: false
            iskeymgr_creator: false
            iskeymgr_owner: false
            size: 48
            offset: 20056
          }
          {
            name: SECRET1
            variant: Buffered
            secret: true
            sw_digest: false
            hw_digest: true
            write_lock: Digest
            read_lock: Digest
            key_sel: Secret1Key
            integrity: true
            bkout_type: false
            zeroizable: true
            skip_sw_header: true
            items:
            [
              {
                name: SRAM_DATA_KEY_SEED
                inv_default: 69863303690126452913563553037773258116
                size: 16
                isdigest: false
                iszer: false
                ismubi: false
                iskeymgr_creator: false
                iskeymgr_owner: false
                absorb: false
                offset: 20104
              }
              {
                name: SECRET1_DIGEST
                size: 8
                offset: 20120
                ismubi: false
                isdigest: true
                iszer: false
                inv_default: 12352438367519599259
                iskeymgr_creator: false
                iskeymgr_owner: false
              }
              {
                name: SECRET1_ZER
                size: 8
                offset: 20128
                ismubi: false
                isdigest: false
                iszer: true
                inv_default: 0
                iskeymgr_creator: false
                iskeymgr_owner: false
              }
            ]
            desc:
              '''
              Secret partition 1.
              This contains the SRAM scrambling key seed.
              '''
            absorb: false
            iskeymgr_creator: false
            iskeymgr_owner: false
            size: 32
            offset: 20104
          }
          {
            name: SECRET2
            variant: Buffered
            secret: true
            sw_digest: false
            hw_digest: true
            write_lock: Digest
            read_lock: Digest
            key_sel: Secret2Key
            integrity: true
            bkout_type: false
            zeroizable: true
            skip_sw_header: true
            items:
            [
              {
                name: RMA_TOKEN
                inv_default: 316928147852353239067110430966290084938
                size: 16
                isdigest: false
                iszer: false
                ismubi: false
                iskeymgr_creator: false
                iskeymgr_owner: false
                absorb: false
                offset: 20136
              }
              {
                name: CREATOR_ROOT_KEY_SHARE0
                inv_default: 7902800436012805411294651361522722082033268323043717797799699848422947779140
                size: 32
                iskeymgr_creator: true
                isdigest: false
                iszer: false
                ismubi: false
                iskeymgr_owner: false
                absorb: false
                offset: 20152
              }
              {
                name: CREATOR_ROOT_KEY_SHARE1
                inv_default: 44801230425435186956258274366201864788170307061535737679846747097832992094144
                size: 32
                iskeymgr_creator: true
                isdigest: false
                iszer: false
                ismubi: false
                iskeymgr_owner: false
                absorb: false
                offset: 20184
              }
              {
                name: CREATOR_SEED
                inv_default: 618893265675549456377841011005023430960191591985442350756386031168057610184
                size: 32
                iskeymgr_creator: true
                isdigest: false
                iszer: false
                ismubi: false
                iskeymgr_owner: false
                absorb: false
                offset: 20216
              }
              {
                name: SECRET2_DIGEST
                size: 8
                offset: 20248
                ismubi: false
                isdigest: true
                iszer: false
                inv_default: 12211039200127545828
                iskeymgr_creator: false
                iskeymgr_owner: false
              }
              {
                name: SECRET2_ZER
                size: 8
                offset: 20256
                ismubi: false
                isdigest: false
                iszer: true
                inv_default: 0
                iskeymgr_creator: false
                iskeymgr_owner: false
              }
            ]
            desc:
              '''
              Secret partition 2.
              This contains RMA unlock token, creator root key, and creator seed.
              '''
            absorb: false
            iskeymgr_creator: true
            iskeymgr_owner: false
            size: 128
            offset: 20136
          }
          {
            name: SECRET3
            variant: Buffered
            secret: true
            sw_digest: false
            hw_digest: true
            write_lock: Digest
            read_lock: Digest
            key_sel: Secret3Key
            integrity: true
            bkout_type: false
            zeroizable: true
            skip_sw_header: true
            items:
            [
              {
                name: OWNER_SEED
                inv_default: 10599371899915034057897987994560919318593524221583877200182626631097778048814
                size: 32
                iskeymgr_owner: true
                isdigest: false
                iszer: false
                ismubi: false
                iskeymgr_creator: false
                absorb: false
                offset: 20264
              }
              {
                name: SECRET3_DIGEST
                size: 8
                offset: 20296
                ismubi: false
                isdigest: true
                iszer: false
                inv_default: 3695109256757431018
                iskeymgr_creator: false
                iskeymgr_owner: false
              }
              {
                name: SECRET3_ZER
                size: 8
                offset: 20304
                ismubi: false
                isdigest: false
                iszer: true
                inv_default: 0
                iskeymgr_creator: false
                iskeymgr_owner: false
              }
            ]
            desc:
              '''
              Secret partition 3.
              This contains the owner seed.
              '''
            absorb: false
            iskeymgr_creator: false
            iskeymgr_owner: true
            size: 48
            offset: 20264
          }
          {
            name: SECRET4
            variant: Buffered
            secret: true
            sw_digest: false
            hw_digest: true
            write_lock: Digest
            read_lock: Digest
            key_sel: Secret4Key
            integrity: true
            bkout_type: false
            zeroizable: true
            skip_sw_header: true
            items:
            [
              {
                name: UCIE_CTA_SEED_SHARE0
                inv_default: 1203977166749760650602329107067535620483501281825550000960003188310369458025
                size: 32
                iskeymgr_owner: true
                isdigest: false
                iszer: false
                ismubi: false
                iskeymgr_creator: false
                absorb: false
                offset: 20312
              }
              {
                name: UCIE_CTA_SEED_SHARE1
                inv_default: 15262142047031988005251309748757925346903988807302050625537529218857981668357
                size: 32
                iskeymgr_owner: true
                isdigest: false
                iszer: false
                ismubi: false
                iskeymgr_creator: false
                absorb: false
                offset: 20344
              }
              {
                name: SECRET4_DIGEST
                size: 8
                offset: 20376
                ismubi: false
                isdigest: true
                iszer: false
                inv_default: 5616004543374932184
                iskeymgr_creator: false
                iskeymgr_owner: false
              }
              {
                name: SECRET4_ZER
                size: 8
                offset: 20384
                ismubi: false
                isdigest: false
                iszer: true
                inv_default: 0
                iskeymgr_creator: false
                iskeymgr_owner: false
              }
            ]
            desc:
              '''
              Secret partition 4.
              This contains the UCIe Chiplet Trust Anchor (CTA) seed.
              '''
            absorb: false
            iskeymgr_creator: false
            iskeymgr_owner: true
            size: 80
            offset: 20312
          }
          {
            name: LIFE_CYCLE
            variant: LifeCycle
            secret: false
            sw_digest: false
            hw_digest: false
            write_lock: None
            read_lock: None
            key_sel: NoKey
            integrity: true
            bkout_type: false
            skip_sw_header: true
            items:
            [
              {
                name: LC_TRANSITION_CNT
                inv_default: 38159489859871528012014545775033726014562581088732829659171289668783823807118634623100944391765786463798185715886804
                size: 48
                isdigest: false
                iszer: false
                ismubi: false
                iskeymgr_creator: false
                iskeymgr_owner: false
                absorb: false
                offset: 20392
              }
              {
                name: LC_STATE
                inv_default: 1346938694073743506210604571907290247744495844309767318051901381616023841411277056210752640269890
                size: 40
                isdigest: false
                iszer: false
                ismubi: false
                iskeymgr_creator: false
                iskeymgr_owner: false
                absorb: false
                offset: 20440
              }
            ]
            desc:
              '''
              Lifecycle partition.
              This contains lifecycle transition count and state. This partition
              cannot be locked since the life cycle state needs to advance to RMA
              in-field. Note that while this partition is not marked secret, it
              is not readable nor writable via the DAI. Only the LC controller
              can access this partition, and even via the LC controller it is not
              possible to read the raw manufacturing life cycle state in encoded
              form, since that encoding is considered a netlist secret. The LC
              controller only exposes a decoded version of this state.
              '''
            absorb: false
            iskeymgr_creator: false
            iskeymgr_owner: false
            zeroizable: false
            size: 88
            offset: 20392
          }
        ]
      }
    }
    {
      name: lc_ctrl
      type: lc_ctrl
      base_addrs:
      {
        regs:
        {
          hart: 0x30150000
        }
        dmi:
        {
          soc_dbg: 0x3000
        }
      }
      memory: {}
      param_list:
      [
        {
          name: RndCnstLcKeymgrDivInvalid
          desc: Diversification value used for all invalid life cycle states.
          type: lc_ctrl_pkg::lc_keymgr_div_t
          randcount: 128
          randtype: data
          name_top: RndCnstLcCtrlLcKeymgrDivInvalid
          default: 0xd8fda7dd235685b52f3c80047adcc7e3
          randwidth: 128
        }
        {
          name: RndCnstLcKeymgrDivTestUnlocked
          desc: Diversification value used for the TEST_UNLOCKED* life cycle states.
          type: lc_ctrl_pkg::lc_keymgr_div_t
          randcount: 128
          randtype: data
          name_top: RndCnstLcCtrlLcKeymgrDivTestUnlocked
          default: 0x77dd041aaffbc1dfdab41c30880f64b5
          randwidth: 128
        }
        {
          name: RndCnstLcKeymgrDivDev
          desc: Diversification value used for the DEV life cycle state.
          type: lc_ctrl_pkg::lc_keymgr_div_t
          randcount: 128
          randtype: data
          name_top: RndCnstLcCtrlLcKeymgrDivDev
          default: 0x7ceb7e57f7c98b052786311d5e97e8f1
          randwidth: 128
        }
        {
          name: RndCnstLcKeymgrDivProduction
          desc: Diversification value used for the PROD/PROD_END life cycle states.
          type: lc_ctrl_pkg::lc_keymgr_div_t
          randcount: 128
          randtype: data
          name_top: RndCnstLcCtrlLcKeymgrDivProduction
          default: 0x1887b129eda81399ecef31c20932fea4
          randwidth: 128
        }
        {
          name: RndCnstLcKeymgrDivRma
          desc: Diversification value used for the RMA life cycle state.
          type: lc_ctrl_pkg::lc_keymgr_div_t
          randcount: 128
          randtype: data
          name_top: RndCnstLcCtrlLcKeymgrDivRma
          default: 0xbe4c50e1b7dde95e6eb2922b1ae5a610
          randwidth: 128
        }
        {
          name: RndCnstInvalidTokens
          desc: Compile-time random bits used for invalid tokens in the token mux
          type: lc_ctrl_pkg::lc_token_mux_t
          randcount: 1024
          randtype: data
          name_top: RndCnstLcCtrlInvalidTokens
          default: 0xd471b0f5bccf1f0033081437f2926ffec64809ea0d7a4ff66188c135c7c02d3544c0cd5899a6102ac52c3399f857ba1734be633e4791548eb20a6ea1d8935f5076924e87e9fc4e7c979c1cfe522c6f5d30de56fab59a80403ab26b19d424c530dcb1e02cb18aea668efdf8f9e52992fbfa810882a8d97449c51b5624a45097a8
          randwidth: 1024
        }
      ]
    }
    {
      name: alert_handler
      type: alert_handler
      base_addrs:
      {
        null:
        {
          hart: 0x30160000
        }
      }
      memory: {}
      param_list:
      [
        {
          name: RndCnstLfsrSeed
          desc: Compile-time random bits for initial LFSR seed
          type: alert_handler_pkg::lfsr_seed_t
          randcount: 32
          randtype: data
          name_top: RndCnstAlertHandlerLfsrSeed
          default: 0x1554f9f0
          randwidth: 32
        }
        {
          name: RndCnstLfsrPerm
          desc: Compile-time random permutation for LFSR output
          type: alert_handler_pkg::lfsr_perm_t
          randcount: 32
          randtype: perm
          name_top: RndCnstAlertHandlerLfsrPerm
          default: 0x9070e9fcb1653b94d5fe1035b42886e59b038d77
          randwidth: 160
        }
      ]
      template_type: alert_handler
    }
    {
      name: sram_ctrl_ret_aon
      type: sram_ctrl
      base_addrs:
      {
        regs:
        {
          hart: 0x30500000
        }
        ram:
        {
          hart: 0x30600000
        }
      }
      memory:
      {
        ram:
        {
          label: ram_ret_aon
          swaccess: rw
          data_intg_passthru: "true"
          exec: True
          byte_write: True
          size: 0x1000
        }
      }
      param_list:
      [
        {
          name: RndCnstSramKey
          desc: Compile-time random reset value for SRAM scrambling key.
          type: otp_ctrl_pkg::sram_key_t
          randcount: 128
          randtype: data
          name_top: RndCnstSramCtrlRetAonSramKey
          default: 0xbfaf404e44fb760d62fd0913a1d1f806
          randwidth: 128
        }
        {
          name: RndCnstSramNonce
          desc: Compile-time random reset value for SRAM scrambling nonce.
          type: otp_ctrl_pkg::sram_nonce_t
          randcount: 128
          randtype: data
          name_top: RndCnstSramCtrlRetAonSramNonce
          default: 0x1eab247199e2f2dfaf873e4da6728554
          randwidth: 128
        }
        {
          name: RndCnstLfsrSeed
          desc: Compile-time random bits for initial LFSR seed
          type: sram_ctrl_pkg::lfsr_seed_t
          randcount: 64
          randtype: data
          name_top: RndCnstSramCtrlRetAonLfsrSeed
          default: 0x2657c1e80eb373b
          randwidth: 64
        }
        {
          name: RndCnstLfsrPerm
          desc: Compile-time random permutation for LFSR output
          type: sram_ctrl_pkg::lfsr_perm_t
          randcount: 64
          randtype: perm
          name_top: RndCnstSramCtrlRetAonLfsrPerm
          default: 0xc39ff162c71606f0f63cb68a42d55f1be13c66e5e194e0a07a6c919d4307ec801216a9226ebdf3e133498fd769a35eb4
          randwidth: 384
        }
      ]
    }
    {
      name: aes
      type: aes
      base_addrs:
      {
        null:
        {
          hart: 0x21100000
        }
      }
      memory: {}
      param_list:
      [
        {
          name: RndCnstClearingLfsrSeed
          desc: Default seed of the PRNG used for register clearing.
          type: aes_pkg::clearing_lfsr_seed_t
          randcount: 64
          randtype: data
          name_top: RndCnstAesClearingLfsrSeed
          default: 0x9e9c4b4a0d8543ce
          randwidth: 64
        }
        {
          name: RndCnstClearingLfsrPerm
          desc: Permutation applied to the LFSR of the PRNG used for clearing.
          type: aes_pkg::clearing_lfsr_perm_t
          randcount: 64
          randtype: perm
          name_top: RndCnstAesClearingLfsrPerm
          default: 0x6aae42056d5e72db3b8cf2d3fafcb3f67babe0037a65d33f84a39b231a495e41501341b74b08910c75657e8f18da6520
          randwidth: 384
        }
        {
          name: RndCnstClearingSharePerm
          desc: Permutation applied to the clearing PRNG output for clearing the second share of registers.
          type: aes_pkg::clearing_lfsr_perm_t
          randcount: 64
          randtype: perm
          name_top: RndCnstAesClearingSharePerm
          default: 0x2597f0f58751dac483a22dd594a427cb1ba1154afa7b5fd332a07cb7b81b3862e41ef5e9ce301c5b4e483c299ae3e344
          randwidth: 384
        }
        {
          name: RndCnstMaskingLfsrSeed
          desc: Default seed of the PRNG used for masking.
          type: aes_pkg::masking_lfsr_seed_t
          randcount: 288
          randtype: data
          name_top: RndCnstAesMaskingLfsrSeed
          default: 0xccf342b6ccc8bc7830166b881be409b32d7c85874e196b2fb8d914aaca03fda87448320d
          randwidth: 288
        }
        {
          name: RndCnstMaskingLfsrPerm
          desc: Permutation applied to the output of the PRNG used for masking.
          type: aes_pkg::masking_lfsr_perm_t
          randcount: 160
          randtype: perm
          name_top: RndCnstAesMaskingLfsrPerm
          default: 0xb883307107a856c49173286110e8e7f2a906d50615b222c8f6e68167754872537971552217c633157600a899967054f0f004e8c0693013d2d41041a64943f5f92141e537d1c513c3946566a9a089d34261f359513761975969e384a1d03129843748d814c18205a9f9b82653e6b4b3a3b291b5942582f097062277e712340554d45804466788a365c0d8b47690c5d91247330847b832e6f72282b79489c025e
          randwidth: 1280
        }
      ]
    }
    {
      name: kmac
      type: kmac
      base_addrs:
      {
        null:
        {
          hart: 0x21120000
        }
      }
      memory: {}
      param_list:
      [
        {
          name: RndCnstLfsrSeed
          desc: Compile-time random data for PRNG default seed
          type: kmac_pkg::lfsr_seed_t
          randcount: 288
          randtype: data
          name_top: RndCnstKmacLfsrSeed
          default: 0x2e23903c838ff791cf76c37e6624858d539c7008fcb6bd8ec29c02d3bf9b0953c9c21f0f
          randwidth: 288
        }
        {
          name: RndCnstLfsrPerm
          desc: Compile-time random permutation for PRNG output
          type: kmac_pkg::lfsr_perm_t
          randcount: 800
          randtype: perm
          name_top: RndCnstKmacLfsrPerm
          default: 0xc2d588857c506104aa593d61e5fa9aa841d9912369020830712c8328ec0767e973124a9ac4949f0371f199a0890ec2ca4f08490eb40e36010f31fa4c90991086bb4adab3b4ad56dee2cea3c4ca623e27a44e4338760d086b0a6c5d2d4a6ed5bbdbd27a0a0bc8392612b80f85d6d000082be18497a54802fa320a10e497235c0096f26563e17c5c7e6637e9000defeb2c350f12ca3ea6b96ff42a725109605843a0e73b9ccb80b1c048a5329879ba293e87f696c11f00a6b9ed16c6160e3863c3083ce62c51576299442bd458d9462ee3a56e54a19b0e453867753dc830da727eca13e2d42e870382e1cd737b192a707779670804014643e4a57a636f554e5d9393519a25abaf9145a679c98639a93143d7c56758ab61a44e6e1651ea313510d1484c394f222c134ca803e505446af541a83a2d78b0b89d2502014d880a233e9eb3d66318bead2302a95c089fb4b976745599fdff902a2169122d5796d1fe7353e8de236c5df46dcc341db43adb214fd6eedd526dab58daa61d009253860286f2a46cc59054e76700505c401bcbf7bdd322a3386a6d5860478643568ff99d461d2ed96f12891907d0c0108ac48626c406a650112722a552fd9e45465c45aa8678bed19c68183a14009041c1c428d311b5ebb7d631357b2de06470e0a2cc286ecc72d937165809b166086b9893c66ca4a1156c3dad9a9304222b9f5e9c11d933581823094787b026d2af139844bd158dc759f39da462a6bf3d1fc6faa9112f443dde41ec0496757a29f02e2e750799fb1d9460b1a30c825af6254b72969b8d480e1ea254478585e85c6244eb0bf16c9a5f0a831f6e6ada151f37b1184cbc1603fc1e5529cbbb18062745062c48775bab786095d5dbeda006c6476970679478352d2c0ee515ce331683bd6dc28ba50829c61880d914546c79bdd5ad5bf1196f87e96c35f6538c1ab21c6b31b618ae7e0df35c1e726ba060d118e1d70481053025fcdb0228a5331515c2b430b4ae24738e8824c1a2aca85c6866a926631175f6e8789cfb25e675c0d24ae2bb2a8b908e1e2b3483143a9344ec274f4b69e25f4bc65ac853031022be4ba329d071e48f0317dddc749094fe3a0cecd971a3b84d594819a08fe2516ac3aeb1055e718fc1caf155e078d23203e6578cf068599601980b585042f708ca09ea89922154a0d20ea22500fb5c9645dd9a582c8c0101982664ea35242e66db1731f1e7ca8e6591a220d696adca9e5634d8a36133676f0266923244a232be9041fc6803aae6193dc2a405dae4ec5ae7b26c6e8a0f7b4c7550c4bbda035e2d94de058f7053887d475366c2443c49aba9a2ba455781f58e695addb7ac5550aa7c6c922c046cb16ce3748757cb9211c32470652ad8b11063daf3a51388fea59368d7f5b5
          randwidth: 8000
        }
        {
          name: RndCnstBufferLfsrSeed
          desc: Compile-time random data for PRNG buffer default seed
          type: kmac_pkg::buffer_lfsr_seed_t
          randcount: 800
          randtype: data
          name_top: RndCnstKmacBufferLfsrSeed
          default: 0x69fea708041bce69f5c7420202036921f4ed455d10936666d7b149c04d22de24fba09d5aca99a14284b71ef2cde4ead7ed52aed48f5eb6d2cb4dccaacd87ccaba001df7415a41db011bd004f159b46c632e985f02b0c4b2a48c02a505578995ad223c61
          randwidth: 800
        }
        {
          name: RndCnstMsgPerm
          desc: Compile-time random permutation for LFSR Message output
          type: kmac_pkg::msg_perm_t
          randcount: 64
          randtype: perm
          name_top: RndCnstKmacMsgPerm
          default: 0x6193f54008b1c09f017671eea04e24d829bff72306b6a87371181b9770df52fad734b58ae5e5634f4ed214ee9ab29f88
          randwidth: 384
        }
      ]
    }
    {
      name: otbn
      type: otbn
      base_addrs:
      {
        null:
        {
          hart: 0x21130000
        }
      }
      memory: {}
      param_list:
      [
        {
          name: RndCnstUrndPrngSeed
          desc: Default seed of the PRNG used for URND.
          type: otbn_pkg::urnd_prng_seed_t
          randcount: 256
          randtype: data
          name_top: RndCnstOtbnUrndPrngSeed
          default: 0x35e21dc1f0dc50f613305a3bd0649f946dfde30b39e0930f59dd2b3f356eac67
          randwidth: 256
        }
        {
          name: RndCnstOtbnKey
          desc: Compile-time random reset value for IMem/DMem scrambling key.
          type: otp_ctrl_pkg::otbn_key_t
          randcount: 128
          randtype: data
          name_top: RndCnstOtbnOtbnKey
          default: 0xc8e02d98b9444c530cf9f2c6c8eb6553
          randwidth: 128
        }
        {
          name: RndCnstOtbnNonce
          desc: Compile-time random reset value for IMem/DMem scrambling nonce.
          type: otp_ctrl_pkg::otbn_nonce_t
          randcount: 64
          randtype: data
          name_top: RndCnstOtbnOtbnNonce
          default: 0x849a513ad5bc3c08
          randwidth: 64
        }
      ]
    }
    {
      name: keymgr_dpe
      type: keymgr_dpe
      base_addrs:
      {
        null:
        {
          hart: 0x21140000
        }
      }
      memory: {}
      param_list:
      [
        {
          name: RndCnstLfsrSeed
          desc: Compile-time random bits for initial LFSR seed
          type: keymgr_pkg::lfsr_seed_t
          randcount: 64
          randtype: data
          name_top: RndCnstKeymgrDpeLfsrSeed
          default: 0x7bc188d7d33f57b2
          randwidth: 64
        }
        {
          name: RndCnstLfsrPerm
          desc: Compile-time random permutation for LFSR output
          type: keymgr_pkg::lfsr_perm_t
          randcount: 64
          randtype: perm
          name_top: RndCnstKeymgrDpeLfsrPerm
          default: 0x64917d9a72cfefc948fad729c57b060cac3479345ad56032e9b564a39aa3deb89807f5333af3611207c7e2ed9230241d
          randwidth: 384
        }
        {
          name: RndCnstRandPerm
          desc: Compile-time random permutation for entropy used in share overriding
          type: keymgr_pkg::rand_perm_t
          randcount: 32
          randtype: perm
          name_top: RndCnstKeymgrDpeRandPerm
          default: 0x7c44a3b25d01a64b417ff60a1be79b70da84d754
          randwidth: 160
        }
        {
          name: RndCnstRevisionSeed
          desc: Compile-time random bits for revision seed
          type: keymgr_pkg::seed_t
          randcount: 256
          randtype: data
          name_top: RndCnstKeymgrDpeRevisionSeed
          default: 0x951e74c5b4241377963dc7f7e11a33ed9ed3d7b32e6e9ec756eec0d713707398
          randwidth: 256
        }
        {
          name: RndCnstSoftOutputSeed
          desc: Compile-time random bits for software generation seed
          type: keymgr_pkg::seed_t
          randcount: 256
          randtype: data
          name_top: RndCnstKeymgrDpeSoftOutputSeed
          default: 0xb3c4bf69f9b78701af8bce26443c9c0c05cfcffae5b001e66f8b69d73dc5679c
          randwidth: 256
        }
        {
          name: RndCnstHardOutputSeed
          desc: Compile-time random bits for hardware generation seed
          type: keymgr_pkg::seed_t
          randcount: 256
          randtype: data
          name_top: RndCnstKeymgrDpeHardOutputSeed
          default: 0x54eece993b065a5897ba86583cafcba5c198863ab538ed09efd6aa8778726fc0
          randwidth: 256
        }
        {
          name: RndCnstAesSeed
          desc: Compile-time random bits for generation seed when aes destination selected
          type: keymgr_pkg::seed_t
          randcount: 256
          randtype: data
          name_top: RndCnstKeymgrDpeAesSeed
          default: 0x8fdb91fe718cf787475f9b6c633de89cc3671e2380a788af2bd5c4331e3c2c3
          randwidth: 256
        }
        {
          name: RndCnstKmacSeed
          desc: Compile-time random bits for generation seed when kmac destination selected
          type: keymgr_pkg::seed_t
          randcount: 256
          randtype: data
          name_top: RndCnstKeymgrDpeKmacSeed
          default: 0xaa6c060577d3b699444600e43a5715f3e99a5fe4c782dec5de40f7f2eeef984
          randwidth: 256
        }
        {
          name: RndCnstOtbnSeed
          desc: Compile-time random bits for generation seed when otbn destination selected
          type: keymgr_pkg::seed_t
          randcount: 256
          randtype: data
          name_top: RndCnstKeymgrDpeOtbnSeed
          default: 0xbcb9f66378919fbe9783b33a85ac60a1b91abece848f9c9273044dad9dd32948
          randwidth: 256
        }
        {
          name: RndCnstNoneSeed
          desc: Compile-time random bits for generation seed when no destination selected
          type: keymgr_pkg::seed_t
          randcount: 256
          randtype: data
          name_top: RndCnstKeymgrDpeNoneSeed
          default: 0x5e173010f2ce7bf2e71d2dc254a70469e764c65d17c25e9c496f06e631daae31
          randwidth: 256
        }
        {
          name: RndCnstManufKeyShare0
          desc: Compile-time random bits for manufacturing key share 0
          type: keymgr_pkg::seed_t
          randcount: 256
          randtype: data
          name_top: RndCnstKeymgrDpeManufKeyShare0
          default: 0x17edc7522e5b0e6aa034ddf160ff98e5916d6f44a718e526b69d6e575de83da8
          randwidth: 256
        }
        {
          name: RndCnstManufKeyShare1
          desc: Compile-time random bits for manufacturing key share 1
          type: keymgr_pkg::seed_t
          randcount: 256
          randtype: data
          name_top: RndCnstKeymgrDpeManufKeyShare1
          default: 0xa33a86e08e65bca8644f5ee8768ef3e4128c330a39954437a72f580014f8eb4a
          randwidth: 256
        }
      ]
    }
    {
      name: csrng
      type: csrng
      base_addrs:
      {
        null:
        {
          hart: 0x21150000
        }
      }
      memory: {}
      param_list:
      [
        {
          name: RndCnstCsKeymgrDivNonProduction
          desc: Compile-time random bits for csrng state group diversification value
          type: csrng_pkg::cs_keymgr_div_t
          randcount: 384
          randtype: data
          name_top: RndCnstCsrngCsKeymgrDivNonProduction
          default: 0xfc697dcbd4904b71f3c4b9f5e99d8b1fc8feb6d69b761336cb33584699bb165d148b0dddc590366a1355261ab9dcfada
          randwidth: 384
        }
        {
          name: RndCnstCsKeymgrDivProduction
          desc: Compile-time random bits for csrng state group diversification value
          type: csrng_pkg::cs_keymgr_div_t
          randcount: 384
          randtype: data
          name_top: RndCnstCsrngCsKeymgrDivProduction
          default: 0xae79555d0e25682d1d3ba96ef633827ac22769edf3b646f7378049e629b0eb423c5e451571a80f5f842cb0c356ba065c
          randwidth: 384
        }
      ]
    }
    {
      name: sram_ctrl_main
      type: sram_ctrl
      base_addrs:
      {
        regs:
        {
          hart: 0x211c0000
        }
        ram:
        {
          hart: 0x10000000
        }
      }
      memory:
      {
        ram:
        {
          label: ram_main
          swaccess: rw
          data_intg_passthru: "true"
          exec: True
          byte_write: True
          size: 0x10000
        }
      }
      param_list:
      [
        {
          name: RndCnstSramKey
          desc: Compile-time random reset value for SRAM scrambling key.
          type: otp_ctrl_pkg::sram_key_t
          randcount: 128
          randtype: data
          name_top: RndCnstSramCtrlMainSramKey
          default: 0x30ed9f924e9e46717a83c5159f938f5c
          randwidth: 128
        }
        {
          name: RndCnstSramNonce
          desc: Compile-time random reset value for SRAM scrambling nonce.
          type: otp_ctrl_pkg::sram_nonce_t
          randcount: 128
          randtype: data
          name_top: RndCnstSramCtrlMainSramNonce
          default: 0x27bf3ebcb99fa1f48f1d4f94038cfa87
          randwidth: 128
        }
        {
          name: RndCnstLfsrSeed
          desc: Compile-time random bits for initial LFSR seed
          type: sram_ctrl_pkg::lfsr_seed_t
          randcount: 64
          randtype: data
          name_top: RndCnstSramCtrlMainLfsrSeed
          default: 0xfa5e396be143c84
          randwidth: 64
        }
        {
          name: RndCnstLfsrPerm
          desc: Compile-time random permutation for LFSR output
          type: sram_ctrl_pkg::lfsr_perm_t
          randcount: 64
          randtype: perm
          name_top: RndCnstSramCtrlMainLfsrPerm
          default: 0xc5fe8bd808c6473b7da9349c5b2905675781b947665e12a0ddbc03fc8602afe56fd0e9509e8e0768f244322b3bf0de69
          randwidth: 384
        }
      ]
    }
    {
      name: sram_ctrl_mbox
      type: sram_ctrl
      base_addrs:
      {
        regs:
        {
          hart: 0x211d0000
        }
        ram:
        {
          hart: 0x11000000
        }
      }
      memory:
      {
        ram:
        {
          label: ram_mbox
          swaccess: rw
          data_intg_passthru: "true"
          exec: False
          byte_write: True
          size: 0x1000
        }
      }
      param_list:
      [
        {
          name: RndCnstSramKey
          desc: Compile-time random reset value for SRAM scrambling key.
          type: otp_ctrl_pkg::sram_key_t
          randcount: 128
          randtype: data
          name_top: RndCnstSramCtrlMboxSramKey
          default: 0xdd0ee9b7c570caf8c9a2bb12853b8785
          randwidth: 128
        }
        {
          name: RndCnstSramNonce
          desc: Compile-time random reset value for SRAM scrambling nonce.
          type: otp_ctrl_pkg::sram_nonce_t
          randcount: 128
          randtype: data
          name_top: RndCnstSramCtrlMboxSramNonce
          default: 0xcbc77f0ce1a68150a2eb908932e470ee
          randwidth: 128
        }
        {
          name: RndCnstLfsrSeed
          desc: Compile-time random bits for initial LFSR seed
          type: sram_ctrl_pkg::lfsr_seed_t
          randcount: 64
          randtype: data
          name_top: RndCnstSramCtrlMboxLfsrSeed
          default: 0x5a9b29bcd69d5822
          randwidth: 64
        }
        {
          name: RndCnstLfsrPerm
          desc: Compile-time random permutation for LFSR output
          type: sram_ctrl_pkg::lfsr_perm_t
          randcount: 64
          randtype: perm
          name_top: RndCnstSramCtrlMboxLfsrPerm
          default: 0x549fb5af66fa19607703d0f47cc34abe0931c27ed32c7b44f17e1afe879c452519ce20a63a36083f2a6e165aa1439b1d
          randwidth: 384
        }
      ]
    }
    {
      name: rom_ctrl0
      type: rom_ctrl
      base_addrs:
      {
        rom:
        {
          hart: 0x00008000
        }
        regs:
        {
          hart: 0x211e0000
        }
      }
      memory:
      {
        rom:
        {
          label: rom0
          swaccess: ro
          data_intg_passthru: True
          exec: True
          byte_write: False
          size: 0x8000
        }
      }
      param_list:
      [
        {
          name: RndCnstScrNonce
          desc: Fixed nonce used for address / data scrambling
          type: bit [63:0]
          randcount: 64
          randtype: data
          name_top: RndCnstRomCtrl0ScrNonce
          default: 0xca3a3b23f3ad6160
          randwidth: 64
        }
        {
          name: RndCnstScrKey
          desc: Randomised constant used as a scrambling key for ROM data
          type: bit [127:0]
          randcount: 128
          randtype: data
          name_top: RndCnstRomCtrl0ScrKey
          default: 0x22b58327851823e1ee2cf4ff8648130f
          randwidth: 128
        }
      ]
    }
    {
      name: rom_ctrl1
      type: rom_ctrl
      base_addrs:
      {
        rom:
        {
          hart: 0x00020000
        }
        regs:
        {
          hart: 0x211e1000
        }
      }
      memory:
      {
        rom:
        {
          label: rom1
          swaccess: ro
          data_intg_passthru: True
          exec: True
          byte_write: False
          size: 0x10000
        }
      }
      param_list:
      [
        {
          name: RndCnstScrNonce
          desc: Fixed nonce used for address / data scrambling
          type: bit [63:0]
          randcount: 64
          randtype: data
          name_top: RndCnstRomCtrl1ScrNonce
          default: 0xf73a1526597d396f
          randwidth: 64
        }
        {
          name: RndCnstScrKey
          desc: Randomised constant used as a scrambling key for ROM data
          type: bit [127:0]
          randcount: 128
          randtype: data
          name_top: RndCnstRomCtrl1ScrKey
          default: 0xb7cfab104df77419e37945ab02f5a08c
          randwidth: 128
        }
      ]
    }
    {
      name: rv_core_ibex
      type: rv_core_ibex
      base_addrs:
      {
        cfg:
        {
          hart: 0x211f0000
        }
      }
      memory: {}
      param_list:
      [
        {
          name: RndCnstLfsrSeed
          desc: Default seed of the PRNG used for random instructions.
          type: ibex_pkg::lfsr_seed_t
          randcount: 32
          randtype: data
          name_top: RndCnstRvCoreIbexLfsrSeed
          default: 0x3741b694
          randwidth: 32
        }
        {
          name: RndCnstLfsrPerm
          desc: Permutation applied to the LFSR of the PRNG used for random instructions.
          type: ibex_pkg::lfsr_perm_t
          randcount: 32
          randtype: perm
          name_top: RndCnstRvCoreIbexLfsrPerm
          default: 0x9c9c11762bf2074bf360b5550f99b8395844bf59
          randwidth: 160
        }
        {
          name: RndCnstIbexKeyDefault
          desc: Default icache scrambling key
          type: logic [ibex_pkg::SCRAMBLE_KEY_W-1:0]
          randcount: 128
          randtype: data
          name_top: RndCnstRvCoreIbexIbexKeyDefault
          default: 0x62d367d6b46a43cb19856fe11d0d16ad
          randwidth: 128
        }
        {
          name: RndCnstIbexNonceDefault
          desc: Default icache scrambling nonce
          type: logic [ibex_pkg::SCRAMBLE_NONCE_W-1:0]
          randcount: 64
          randtype: data
          name_top: RndCnstRvCoreIbexIbexNonceDefault
          default: 0x5b7cfc3dc48a4226
          randwidth: 64
        }
      ]
      template_type: rv_core_ibex
    }
  ]
}
