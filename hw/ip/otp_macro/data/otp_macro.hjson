// Copyright lowRISC contributors (OpenTitan project).
// Licensed under the Apache License, Version 2.0, see LICENSE for details.
// SPDX-License-Identifier: Apache-2.0
{
  name:               "otp_macro",
  human_name:         "OTP Macro Wrapper",
  one_line_desc:      "OTP macro simulation model and CSR block",
  one_paragraph_desc: '''
  OTP macro has one-time programmable fuses that configure this top.
  It is tightly coupled to the OTP controller, but placed at the top for
  ease of integration. It contains a CSR block for testing and macro specific
  functionality.
  '''
  // Unique comportable IP identifier defined under KNOWN_CIP_IDS in the regtool.
  cip_id:             "44",
  design_spec:        "../doc",
#  dv_doc:             "../doc/dv",
#  hw_checklist:       "../doc/checklist",
#  sw_checklist:       "/sw/device/lib/dif/dif_pwm",
  revisions: [
    {
      version:            "1.0.0",
      life_stage:         "L1",
      design_stage:       "D1",
      verification_stage: "V1",
      dif_stage:          "S2",
      notes:              "Use OTP to perform block level verification.",
    }
  ]
  clocking: [
    {clock: "clk_i", reset: "rst_ni", primary: true},
  ]
  available_output_list: [
    { name: "test",
      width: 8,
      desc: "Test-related GPIOs. Only active in DFT-enabled life cycle states."
    }
  ],
  bus_interfaces: [
    { protocol: "tlul", direction: "device", name: "prim", racl_support: true }
  ],
  scan: "true", // Enable `scanmode_i` port
  scan_reset: "true", // Enable `scan_rst_ni` port
  scan_en: "true",    // Enable `scan_en_i` port

  available_output_list: [
    { name: "test",
      width: 8,
      desc: "Test-related GPIOs. Only active in DFT-enabled life cycle states."
    }
  ],

  regwidth: "32",
  param_list: [
    { name: "Width",
      desc: "Size of storage words in bits",
      type: "int",
      default: "16",
      local: "false",
    },
    { name: "Depth",
      desc: "Number of words",
      type: "int",
      default: "1024",
      local: "false",
    },
    { name: "SizeWidth",
      desc: "Number of words transferred per access",
      type: "int",
      default: "2",
      local: "false",
    },
    {
      name: "MemInitFile",
      desc: "",
      type: "",
      default: '""',
      expose: "true",
      local: "false",
    },
    {
      name: "VendorTestOffset",
      desc: "",
      type: "int",
      default: "8",
      local: "false",
    },
    {
      name: "VendorTestSize",
      desc: "",
      type: "int",
      default: "8",
      local: "false",
    },
  ],
  alert_list: [],
  features: []
    countermeasures: [
    { name: "BUS.INTEGRITY",
      desc: "End-to-end bus integrity scheme."
    }
  ]
  inter_signal_list: [
    // AST observability control
    { struct: "ast_obs_ctrl",
      type: "uni",
      name: "obs_ctrl",
      act: "rcv",
      package: "ast_pkg"
      desc:    "AST observability control signals."
    }
    // otp macro observe bus
    { struct: "logic",
      type: "uni",
      name: "otp_obs",
      act: "req",
      width: "8",
      package: ""
      desc:    "AST observability bus."
    }
    // Power sequencing signals to AST
    { struct:  "pwr_seq"
      type:    "uni"
      name:    "pwr_seq"
      act:     "req"
      default: "'0"
      package: "otp_macro_pkg"
      desc:    "Power sequencing signals to AST (VDD domain)."
    }
    // Power sequencing signals from AST
    { struct:  "pwr_seq"
      type:    "uni"
      name:    "pwr_seq_h"
      act:     "rcv"
      default: "'0"
      package: "otp_macro_pkg"
      desc:    "Power sequencing signals coming from AST (VCC domain)."
    }
    // OTP dedicated power connection from AST
    { struct:  ""
      type:    "io"
      name:    "ext_voltage_h"
      act:     "none"
      default: "'0"
      package: "",
    }

    // LC_CTRL test enable input
    { struct:  "lc_tx"
      type:    "uni"
      name:    "lc_dft_en"
      act:     "rcv"
      default: "lc_ctrl_pkg::Off"
      package: "lc_ctrl_pkg"
      desc:    '''
               Test enable qualifier coming from life cycle controller.
               This signals enables the TL-UL access port.
               '''
    }
    // Macro specific test signals to/from LC TAP
    { struct:  "otp_test"
      type:    "req_rsp"
      name:    "test"
      act:     "rsp"
      default: "'0"
      package: "otp_macro_pkg"
      desc:    "Vendor test control signals from/to the life cycle TAP."
    }
    // OTP_CTRL Interface
    { struct:  "otp_ctrl_macro"
      type:    "req_rsp"
      name:    "otp"
      act:     "rsp"
      default: "'0"
      package: "otp_ctrl_macro_pkg"
      desc:    "Data interface for the OTP macro."
    }
    // DFT CFG and RSP signals
    { struct:  "otp_cfg"
      type:    "uni"
      name:    "cfg"
      act:     "rcv"
      default: "'0"
      package: "prim_otp_cfg_pkg"
    },
    { struct:  "otp_cfg_rsp"
      type:    "uni"
      name:    "cfg_rsp"
      act:     "req"
      default: "'0"
      package: "prim_otp_cfg_pkg"
    },
    // RACL interface
    { struct:  "racl_policy_vec",
      type:    "uni",
      name:    "racl_policies",
      act:     "rcv",
      package: "top_racl_pkg",
      desc:    '''
        Incoming RACL policy vector from a racl_ctrl instance.
        The policy selection vector (parameter) selects the policy for each register.
      '''
    },
    { struct:  "racl_error_log",
      type:    "uni",
      name:    "racl_error",
      act:     "req",
      width:   "1"
      package: "top_racl_pkg",
      desc:    '''
        RACL error log information of this module.
      '''
    },
  ],

  countermeasures: [
    { name: "LC_CTRL.INTERSIG.MUBI",
      desc: "The life cycle control signals are multibit encoded."
    }
    { name: "TEST.BUS.LC_GATED",
      desc: "Prevent access to test signals and the OTP backdoor interface in non-test lifecycle states."
    }
    { name: "TEST_TL_LC_GATE.FSM.SPARSE",
      desc: "The control FSM inside the TL-UL gating primitive is sparsely encoded."
    }
    { name: "MACRO.MEM.INTEGRITY",
      desc: '''
            The OTP macro employs a vendor-specific integrity scheme at the granularity of the native 16bit OTP words.
            The scheme is able to at least detect single bit errors.
            '''
    }
    { name: "MACRO.MEM.CM",
      desc: "The OTP macro may contain additional vendor-specific countermeasures."
    }
  ]

  registers: {
    prim: [
      { name: "MACRO_CONTROL",
        desc: "fuse macro mode control"
        swaccess: "rw",
        hwaccess: "hro",
        hwext:    "false",
        hwqe:     "true",
        tags: [ // Write to MACRO_CONTROL randomly might cause OTP_ERRORs and illegal sequences
                "excl:CsrAllTests:CsrExclWrite"],
        fields: [
          { bits: "1:0",
            name: "macro_mode",
            desc: "0: standard array, 1: redundancy array, 2: test array",
            resval: "0x0",
          }
          { bits: "2",
            name: "ecc_sel",
            desc: "select ecc array when in redundancy or test modes",
            resval: "0x0",
          }
          { bits: "4:3",
            name: "test_row_col_sel",
            desc: "used to control row or colum selection in test array mode. 00 = 1st test row, 01 = 2nd test row, 10 = 1st test col, 11 = 2nd test col"
            resval: "0x0",
          }
          { bits: "5",
            name: "read_margin",
            desc: "Setting this bit enables fuse reads in high margin mode"
            resval: "0x0",
          }
          { bits: "6",
            name: "ecc_disable",
            desc: "this bit disables ecc fuse writing and read checking"
            resval: "0x0",
          }
          { bits: "7",
            name: "redundancy_autoinit_disable",
            desc: "this bit disables automatic tsmc redundancy flop initialization"
            resval: "0x0",
          }
          { bits: "8"
            swaccess: "ro",
            hwaccess: "hwo",
            name: "reset_allowed"
            desc: "Indicates a SW reset is allowed. For simulation only."
          }
        ]
      },
      { name: "READ_ECC_INFO",
        desc: "ecc info from previous fuse read"
        swaccess: "ro",
        hwaccess: "hwo",
        hwext:    "false",
        hwqe:     "false",
        tags: [ // Write to READ_ECC_INFO randomly might cause OTP_ERRORs and illegal sequences
                "excl:CsrAllTests:CsrExclWrite"],
        fields: [
          { bits: "7:0",
            name: "ecc_info_0",
            desc: "fuse word 0 ecc info",
            resval: "0x0", 
          }
          { bits: "15:8",
            name: "ecc_info_1",
            desc: "fuse word 1 ecc info",
            resval: "0x0",
          }
          { bits: "23:16",
            name: "ecc_info_2",
            desc: "fuse word 2 ecc info",
            resval: "0x0",
          }
          { bits: "31:24",
            name: "ecc_info_3",
            desc: "fuse word 3 ecc info",
            resval: "0x0",
          }
        ]
      },
      { name: "FUSE_WRAPPER_RD_CFG_0",
        desc: "fuse macro wrapper read timing config"
        swaccess: "rw",
        hwaccess: "hro",
        hwext:    "false",
        hwqe:     "true",
        tags: [ // Write to FUSE_WRAPPER_RD_CFG_0 randomly might cause OTP_ERRORs and illegal sequences
                "excl:CsrAllTests:CsrExclWrite"],
        fields: [
          { bits: "11:0",
            name: "TSUR_PD_PS_CYCLES",
            desc: "number oscillator clock cycles to satisfy TSUR_PD_PS timing"
            resval: "0x147",
          }
          { bits: "21:12",
            name: "TSUR_PS_CYCLES",
            desc: "number oscillator clock cycles to satisfy TSUR_PS timing"
            resval: "0x57",
          }
          { bits: "30:22",
            name: "TSUR_PS_CS_CYCLES",
            desc: "number oscillator clock cycles to satisfy TSUR_PS_CS timing"
            resval: "0x40",
          }
        ]
      },
      { name: "FUSE_WRAPPER_RD_CFG_1",
        desc: "fuse macro wrapper read timing config"
        swaccess: "rw",
        hwaccess: "hro",
        hwext:    "false",
        hwqe:     "true",
        tags: [ // Write to this register randomly might cause OTP_ERRORs and illegal sequences
                "excl:CsrAllTests:CsrExclWrite"],
        fields: [
          { bits: "8:0",
            name: "TSUP_PS_CS_CYCLES",
            desc: "number oscillator clock cycles to satisfy TSUP_PS_CS timing"
            resval: "0x40",
          }
          { bits: "18:9",
            name: "TSUP_PS_CYCLES",
            desc: "number oscillator clock cycles to satisfy TSUP_PS timing"
            resval: "0x57",
          }
          { bits: "28:19",
            name: "TSQ_CYCLES",
            desc: "number oscillator clock cycles to satisfy TSQ timing"
            resval: "0x57",
          }
        ]
      },
      { name: "FUSE_WRAPPER_RD_CFG_2",
        desc: "fuse macro wrapper read timing config"
        swaccess: "rw",
        hwaccess: "hro",
        hwext:    "false",
        hwqe:     "true",
        tags: [ // Write to this register randomly might cause OTP_ERRORs and illegal sequences
                "excl:CsrAllTests:CsrExclWrite"],
        fields: [
          { bits: "10:0",
            name: "TSQ_M_CYCLES",
            desc: "number oscillator clock cycles to satisfy TSQ_M timing"
            resval: "0xDA",
          }
          { bits: "24:11",
            name: "TPGM_CYCLES",
            desc: "number oscillator clock cycles to satisfy TPGM timing"
            resval: "0x753",
          }
          { bits: "31:25",
            name: "TSUR_LD_CYCLES",
            desc: "number oscillator clock cycles to satisfy TSUR_LD timing"
            resval: "0x31",
          }
        ]
      },
      { name: "FUSE_WRAPPER_RD_CFG_3",
        desc: "fuse macro wrapper read timing config"
        swaccess: "rw",
        hwaccess: "hro",
        hwext:    "false",
        hwqe:     "true",
        tags: [ // Write to this register randomly might cause OTP_ERRORs and illegal sequences
                "excl:CsrAllTests:CsrExclWrite"],
        fields: [
          { bits: "9:0",
            name: "THR_PS_CYCLES",
            desc: "number oscillator clock cycles to satisfy THR_PS timing"
            resval: "0x5E",
          }
          { bits: "19:10",
            name: "THP_PS_CYCLES",
            desc: "number oscillator clock cycles to satisfy THP_PS timing"
            resval: "0x5E",
          }
          { bits: "28:20",
            name: "THP_CS_CYCLES",
            desc: "number oscillator clock cycles to satisfy THP_CS timing"
            resval: "0x2A",
          }
        ]
      },
      { name: "FUSE_WRAPPER_RD_CFG_4",
        desc: "fuse macro wrapper read timing config"
        swaccess: "rw",
        hwaccess: "hro",
        hwext:    "false",
        hwqe:     "true",
        tags: [ // Write to this register randomly might cause OTP_ERRORs and illegal sequences
                "excl:CsrAllTests:CsrExclWrite"],
        fields: [
          { bits: "8:0",
            name: "THR_CS_CYCLES",
            desc: "number oscillator clock cycles to satisfy THR_CS timing"
            resval: "0x2A",
          }
          { bits: "17:9",
            name: "THP_PS_CS_CYCLES",
            desc: "number oscillator clock cycles to satisfy THP_PS_CS timing"
            resval: "0x35",
          }
          { bits: "26:18",
            name: "THR_PS_CS_CYCLES",
            desc: "number oscillator clock cycles to satisfy THR_PS_CS timing"
            resval: "0x35",
          }
        ]
      },
      { name: "FUSE_WRAPPER_RD_CFG_5",
        desc: "fuse macro wrapper read timing config"
        swaccess: "rw",
        hwaccess: "hro",
        hwext:    "false",
        hwqe:     "true",
        tags: [ // Write to this register randomly might cause OTP_ERRORs and illegal sequences
                "excl:CsrAllTests:CsrExclWrite"],
        fields: [
          { bits: "7:0",
            name: "TSUR_A_CYCLES",
            desc: "number oscillator clock cycles to satisfy TSUR_A timing"
            resval: "0xF",
          }
          { bits: "15:8",
            name: "TSUP_A_CYCLES",
            desc: "number oscillator clock cycles to satisfy TSUP_A timing"
            resval: "0xF",
          }
          { bits: "23:16",
            name: "THP_A_CYCLES",
            desc: "number oscillator clock cycles to satisfy THP_A timing"
            resval: "0xF",
          }
          { bits: "31:24",
            name: "TSUP_LD_CYCLES",
            desc: "number oscillator clock cycles to satisfy TSUP_LD timing"
            resval: "0x31",
          }
        ]
      },
      { name: "FUSE_WRAPPER_RD_CFG_6",
        desc: "fuse macro wrapper read timing config",
        swaccess: "rw",
        hwaccess: "hro",
        hwext:    "false",
        hwqe:     "true",
        tags: [ // Write to this register randomly might cause OTP_ERRORs and illegal sequences
                "excl:CsrAllTests:CsrExclWrite"],
        fields: [
          { bits: "9:0",
            name: "TRD_CYCLES",
            desc: "number oscillator clock cycles to satisfy TRD timing"
            resval: "0x5A",
          }
          { bits: "20:10",
            name: "TRD_M_CYCLES",
            desc: "number oscillator clock cycles to satisfy TRD_M timing"
            resval: "0xDA",
          }
          { bits: "28:21",
            name: "THR_A_CYCLES",
            desc: "number oscillator clock cycles to satisfy THR_A timing"
            resval: "0x13",
          }
        ]
      },
      { name: "FUSE_WRAPPER_RD_CFG_7",
        desc: "fuse macro wrapper read timing config",
        swaccess: "rw",
        hwaccess: "hro",
        hwext:    "false",
        hwqe:     "true",
        tags: [ // Write to this register randomly might cause OTP_ERRORs and illegal sequences
                "excl:CsrAllTests:CsrExclWrite"],
        fields: [
          { bits: "7:0",
            name: "THP_PD_PS_CYCLES",
            desc: "number oscillator clock cycles to satisfy THP_PD_PS timing"
            resval: "0x1B",
          }
          { bits: "15:8",
            name: "DATA_CAPTURE_CYCLES",
            desc: "number oscillator clock cycles to satisfy DATA_CAPTURE timing"
            resval: "0x1",
          }
          { bits: "23:16",
            name: "ADDR_CAPTURE_CYCLES",
            desc: "number oscillator clock cycles to satisfy ADDR_CAPTURE timing"
            resval: "0x1",
          }
        ]
      },
      { name: "FUSE_WRAPPER_RD_CFG_8",
        desc: "fuse macro wrapper read timing config",
        swaccess: "rw",
        hwaccess: "hro",
        hwext:    "false",
        hwqe:     "true",
        tags: [ // Write to this register randomly might cause OTP_ERRORs and illegal sequences
                "excl:CsrAllTests:CsrExclWrite"],
        fields: [
          { bits: "17:0",
            name: "TRIGGER_POWER_DOWN_CYCLES",
            desc: "number oscillator clock cycles to satisfy TRIGGER_POWER_DOWN timing"
            resval: "0x493E",
          }
        ]
      },
      { name: "FUSE_WRAPPER_WR_CFG_0",
        desc: "fuse macro wrapper write timing config"
        swaccess: "rw",
        hwaccess: "hro",
        hwext:    "false",
        hwqe:     "true",
        tags: [ // Write to this register randomly might cause OTP_ERRORs and illegal sequences
                "excl:CsrAllTests:CsrExclWrite"],
        fields: [
          { bits: "11:0",
            name: "TSUR_PD_PS_CYCLES",
            desc: "number oscillator clock cycles to satisfy TSUR_PD_PS timing"
            resval: "0x88",
          }
          { bits: "21:12",
            name: "TSUR_PS_CYCLES",
            desc: "number oscillator clock cycles to satisfy TSUR_PS timing"
            resval: "0x25",
          }
          { bits: "30:22",
            name: "TSUR_PS_CS_CYCLES",
            desc: "number oscillator clock cycles to satisfy TSUR_PS_CS timing"
            resval: "0x1B",
          }
        ]
      },
      { name: "FUSE_WRAPPER_WR_CFG_1",
        desc: "fuse macro wrapper write timing config"
        swaccess: "rw",
        hwaccess: "hro",
        hwext:    "false",
        hwqe:     "true",
        tags: [ // Write to this register randomly might cause OTP_ERRORs and illegal sequences
                "excl:CsrAllTests:CsrExclWrite"],
        fields: [
          { bits: "8:0",
            name: "TSUP_PS_CS_CYCLES",
            desc: "number oscillator clock cycles to satisfy TSUP_PS_CS timing"
            resval: "0x1B",
          }
          { bits: "18:9",
            name: "TSUP_PS_CYCLES",
            desc: "number oscillator clock cycles to satisfy TSUP_PS timing"
            resval: "0x25",
          }
          { bits: "28:19",
            name: "TSQ_CYCLES",
            desc: "number oscillator clock cycles to satisfy TSQ timing"
            resval: "0x24",
          }
        ]
      },
      { name: "FUSE_WRAPPER_WR_CFG_2",
        desc: "fuse macro wrapper write timing config"
        swaccess: "rw",
        hwaccess: "hro",
        hwext:    "false",
        hwqe:     "true",
        tags: [ // Write to this register randomly might cause OTP_ERRORs and illegal sequences
                "excl:CsrAllTests:CsrExclWrite"],
        fields: [
          { bits: "10:0",
            name: "TSQ_M_CYCLES",
            desc: "number oscillator clock cycles to satisfy TSQ_M timing"
            resval: "0x5A",
          }
          { bits: "24:11",
            name: "TPGM_CYCLES",
            desc: "number oscillator clock cycles to satisfy TPGM timing"
            resval: "0x30E",
          }
          { bits: "31:25",
            name: "TSUR_LD_CYCLES",
            desc: "number oscillator clock cycles to satisfy TSUR_LD timing"
            resval: "0x15",
          }
        ]
      },
      { name: "FUSE_WRAPPER_WR_CFG_3",
        desc: "fuse macro wrapper write timing config"
        swaccess: "rw",
        hwaccess: "hro",
        hwext:    "false",
        hwqe:     "true",
        tags: [ // Write to this register randomly might cause OTP_ERRORs and illegal sequences
                "excl:CsrAllTests:CsrExclWrite"],
        fields: [
          { bits: "9:0",
            name: "THR_PS_CYCLES",
            desc: "number oscillator clock cycles to satisfy THR_PS timing"
            resval: "0x27",
          }
          { bits: "19:10",
            name: "THP_PS_CYCLES",
            desc: "number oscillator clock cycles to satisfy THP_PS timing"
            resval: "0x27",
          }
          { bits: "28:20",
            name: "THP_CS_CYCLES",
            desc: "number oscillator clock cycles to satisfy THP_CS timing"
            resval: "0x11",
          }
        ]
      },
      { name: "FUSE_WRAPPER_WR_CFG_4",
        desc: "fuse macro wrapper write timing config"
        swaccess: "rw",
        hwaccess: "hro",
        hwext:    "false",
        hwqe:     "true",
        tags: [ // Write to this register randomly might cause OTP_ERRORs and illegal sequences
                "excl:CsrAllTests:CsrExclWrite"],
        fields: [
          { bits: "8:0",
            name: "THR_CS_CYCLES",
            desc: "number oscillator clock cycles to satisfy THR_CS timing"
            resval: "0x11",
          }
          { bits: "17:9",
            name: "THP_PS_CS_CYCLES",
            desc: "number oscillator clock cycles to satisfy THP_PS_CS timing"
            resval: "0x16",
          }
          { bits: "26:18",
            name: "THR_PS_CS_CYCLES",
            desc: "number oscillator clock cycles to satisfy THR_PS_CS timing"
            resval: "0x16",
          }
        ]
      },
      { name: "FUSE_WRAPPER_WR_CFG_5",
        desc: "fuse macro wrapper write timing config"
        swaccess: "rw",
        hwaccess: "hro",
        hwext:    "false",
        hwqe:     "true",
        tags: [ // Write to this register randomly might cause OTP_ERRORs and illegal sequences
                "excl:CsrAllTests:CsrExclWrite"],
        fields: [
          { bits: "7:0",
            name: "TSUR_A_CYCLES",
            desc: "number oscillator clock cycles to satisfy TSUR_A timing"
            resval: "0x7",
          }
          { bits: "15:8",
            name: "TSUP_A_CYCLES",
            desc: "number oscillator clock cycles to satisfy TSUP_A timing"
            resval: "0x7",
          }
          { bits: "23:16",
            name: "THP_A_CYCLES",
            desc: "number oscillator clock cycles to satisfy THP_A timing"
            resval: "0x8",
          }
          { bits: "31:24",
            name: "TSUP_LD_CYCLES",
            desc: "number oscillator clock cycles to satisfy TSUP_LD timing"
            resval: "0x15",
          }
        ]
      },
      { name: "FUSE_WRAPPER_WR_CFG_6",
        desc: "fuse macro wrapper write timing config",
        swaccess: "rw",
        hwaccess: "hro",
        hwext:    "false",
        hwqe:     "true",
        tags: [ // Write to this register randomly might cause OTP_ERRORs and illegal sequences
                "excl:CsrAllTests:CsrExclWrite"],
        fields: [
          { bits: "9:0",
            name: "TRD_CYCLES",
            desc: "number oscillator clock cycles to satisfy TRD timing"
            resval: "0x25",
          }
          { bits: "20:10",
            name: "TRD_M_CYCLES",
            desc: "number oscillator clock cycles to satisfy TRD_M timing"
            resval: "0x5B",
          }
          { bits: "28:21",
            name: "THR_A_CYCLES",
            desc: "number oscillator clock cycles to satisfy THR_A timing"
            resval: "0x8",
          }
        ]
      },
      { name: "FUSE_WRAPPER_WR_CFG_7",
        desc: "fuse macro wrapper write timing config",
        swaccess: "rw",
        hwaccess: "hro",
        hwext:    "false",
        hwqe:     "true",
        tags: [ // Write to this register randomly might cause OTP_ERRORs and illegal sequences
                "excl:CsrAllTests:CsrExclWrite"],
        fields: [
          { bits: "7:0",
            name: "THP_PD_PS_CYCLES",
            desc: "number oscillator clock cycles to satisfy THP_PD_PS timing"
            resval: "0xB",
          }
          { bits: "15:8",
            name: "DATA_CAPTURE_CYCLES",
            desc: "number oscillator clock cycles to satisfy DATA_CAPTURE timing"
            resval: "0x1",
          }
          { bits: "23:16",
            name: "ADDR_CAPTURE_CYCLES",
            desc: "number oscillator clock cycles to satisfy ADDR_CAPTURE timing"
            resval: "0x1",
          }
        ]
      },
      { name: "FUSE_WRAPPER_WR_CFG_8",
        desc: "fuse macro wrapper write timing config",
        swaccess: "rw",
        hwaccess: "hro",
        hwext:    "false",
        hwqe:     "true",
        tags: [ // Write to this register randomly might cause OTP_ERRORs and illegal sequences
                "excl:CsrAllTests:CsrExclWrite"],
        fields: [
          { bits: "17:0",
            name: "TRIGGER_POWER_DOWN_CYCLES",
            desc: "number oscillator clock cycles to satisfy TRIGGER_POWER_DOWN timing"
            resval: "0x1E85",
          }
        ]
      },
    ]
  }
}
